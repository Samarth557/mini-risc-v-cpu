* +++++++++++++++++++++++++++++++++++++++++++++++++++++
* CDL Netlist:
*
* Cell Name: chip_top
* Netlisted: 2026-10-11 23:56:05
* Pegasus 25.13-s012
* +++++++++++++++++++++++++++++++++++++++++++++++++++++
*.LDD
*.DEVTMPLT 0 MN(nfet_01v8) nfet_01v8_rec nSourceDrain(D) nfet(G) nSourceDrain(S) pwell_all(B)
*.DEVTMPLT 1 MP(pfet_01v8) pfet_01v8_rec pSourceDrain(D) pfet(G) pSourceDrain(S) nwell(B)
*.DEVTMPLT 2 MP(pfet_01v8_lvt) lvtpfet_01v8_rec pSourceDrain(D) lvtpfet(G) pSourceDrain(S) nwell(B)
*.DEVTMPLT 3 MN(nfet_01v8_lvt) lvtnfet_01v8_rec nSourceDrain(D) lvtnfet(G) nSourceDrain(S) pwell_all(B)

* +++++++++++++++++++++++++++++++++++++++++++++++++++++
* Sub cell: NAND2X2_HS
* +++++++++++++++++++++++++++++++++++++++++++++++++++++
.subckt NAND2X2_HS 1 2 VSS Y A B VDD
M0 VDD A Y 2 pfet_01v8 L=1.5e-07 W=1.46e-06 $X=860 $Y=2285 $dt=1
M1 Y A VDD 2 pfet_01v8 L=1.5e-07 W=1.46e-06 $X=1290 $Y=2285 $dt=1
M2 VDD B Y 2 pfet_01v8 L=1.5e-07 W=1.46e-06 $X=1720 $Y=2285 $dt=1
M3 Y B VDD 2 pfet_01v8 L=1.5e-07 W=1.46e-06 $X=2150 $Y=2285 $dt=1
M4 4 A VSS 1 nfet_01v8_lvt L=1.5e-07 W=7.6e-07 $X=860 $Y=395 $dt=3
M5 VSS A 4 1 nfet_01v8_lvt L=1.5e-07 W=7.6e-07 $X=1290 $Y=395 $dt=3
M6 4 B Y 1 nfet_01v8_lvt L=1.5e-07 W=7.6e-07 $X=1720 $Y=395 $dt=3
M7 Y B 4 1 nfet_01v8_lvt L=1.5e-07 W=7.6e-07 $X=2150 $Y=395 $dt=3
** N=54 EP=7 NDC=8 FDC=8 HDC=8
.ends NAND2X2_HS

* +++++++++++++++++++++++++++++++++++++++++++++++++++++
* Sub cell: INVX2_HS
* +++++++++++++++++++++++++++++++++++++++++++++++++++++
.subckt INVX2_HS 1 2 VSS Y A VDD
M0 VDD A Y 2 pfet_01v8 L=1.5e-07 W=1.46e-06 $X=860 $Y=2285 $dt=1
M1 Y A VDD 2 pfet_01v8 L=1.5e-07 W=1.46e-06 $X=1290 $Y=2285 $dt=1
M2 VSS A Y 1 nfet_01v8_lvt L=1.5e-07 W=7.6e-07 $X=860 $Y=590 $dt=3
M3 Y A VSS 1 nfet_01v8_lvt L=1.5e-07 W=7.6e-07 $X=1290 $Y=590 $dt=3
** N=34 EP=6 NDC=4 FDC=4 HDC=4
.ends INVX2_HS

* +++++++++++++++++++++++++++++++++++++++++++++++++++++
* Sub cell: AOI21X1
* +++++++++++++++++++++++++++++++++++++++++++++++++++++
.subckt AOI21X1 1 2 VSS Y A0 B0 A1 VDD
M0 VSS A0 10 1 nfet_01v8 L=1.5e-07 W=7.6e-07 $X=400 $Y=590 $dt=0
M1 10 A1 Y 1 nfet_01v8 L=1.5e-07 W=7.6e-07 $X=830 $Y=590 $dt=0
M2 Y B0 VSS 1 nfet_01v8 L=1.5e-07 W=7.6e-07 $X=1260 $Y=590 $dt=0
M3 8 A0 VDD 2 pfet_01v8 L=1.5e-07 W=1.13e-06 $X=400 $Y=2420 $dt=1
M4 VDD A1 8 2 pfet_01v8 L=1.5e-07 W=1.13e-06 $X=830 $Y=2420 $dt=1
M5 8 B0 Y 2 pfet_01v8 L=1.5e-07 W=1.13e-06 $X=1260 $Y=2420 $dt=1
** N=41 EP=8 NDC=6 FDC=6 HDC=6
.ends AOI21X1

* +++++++++++++++++++++++++++++++++++++++++++++++++++++
* Sub cell: NAND3X4_HS
* +++++++++++++++++++++++++++++++++++++++++++++++++++++
.subckt NAND3X4_HS 1 2 VSS Y A B C VDD
M0 VDD A Y 2 pfet_01v8 L=1.5e-07 W=1.46e-06 $X=860 $Y=2285 $dt=1
M1 Y A VDD 2 pfet_01v8 L=1.5e-07 W=1.46e-06 $X=1290 $Y=2285 $dt=1
M2 VDD A Y 2 pfet_01v8 L=1.5e-07 W=1.46e-06 $X=1720 $Y=2285 $dt=1
M3 Y A VDD 2 pfet_01v8 L=1.5e-07 W=1.46e-06 $X=2150 $Y=2285 $dt=1
M4 VDD B Y 2 pfet_01v8 L=1.5e-07 W=1.46e-06 $X=2580 $Y=2285 $dt=1
M5 Y B VDD 2 pfet_01v8 L=1.5e-07 W=1.46e-06 $X=3010 $Y=2285 $dt=1
M6 VDD B Y 2 pfet_01v8 L=1.5e-07 W=1.46e-06 $X=3440 $Y=2285 $dt=1
M7 Y B VDD 2 pfet_01v8 L=1.5e-07 W=1.46e-06 $X=3870 $Y=2285 $dt=1
M8 VDD C Y 2 pfet_01v8 L=1.5e-07 W=1.46e-06 $X=4820 $Y=2285 $dt=1
M9 Y C VDD 2 pfet_01v8 L=1.5e-07 W=1.46e-06 $X=5250 $Y=2285 $dt=1
M10 VDD C Y 2 pfet_01v8 L=1.5e-07 W=1.46e-06 $X=5680 $Y=2285 $dt=1
M11 Y C VDD 2 pfet_01v8 L=1.5e-07 W=1.46e-06 $X=6110 $Y=2285 $dt=1
M12 5 A VSS 1 nfet_01v8_lvt L=1.5e-07 W=7.6e-07 $X=860 $Y=590 $dt=3
M13 VSS A 5 1 nfet_01v8_lvt L=1.5e-07 W=7.6e-07 $X=1290 $Y=590 $dt=3
M14 5 A VSS 1 nfet_01v8_lvt L=1.5e-07 W=7.6e-07 $X=1720 $Y=590 $dt=3
M15 VSS A 5 1 nfet_01v8_lvt L=1.5e-07 W=7.6e-07 $X=2150 $Y=590 $dt=3
M16 5 B 4 1 nfet_01v8_lvt L=1.5e-07 W=7.6e-07 $X=2580 $Y=590 $dt=3
M17 4 B 5 1 nfet_01v8_lvt L=1.5e-07 W=7.6e-07 $X=3010 $Y=590 $dt=3
M18 5 B 4 1 nfet_01v8_lvt L=1.5e-07 W=7.6e-07 $X=3440 $Y=590 $dt=3
M19 4 B 5 1 nfet_01v8_lvt L=1.5e-07 W=7.6e-07 $X=3870 $Y=590 $dt=3
M20 Y C 4 1 nfet_01v8_lvt L=1.5e-07 W=7.6e-07 $X=4820 $Y=590 $dt=3
M21 4 C Y 1 nfet_01v8_lvt L=1.5e-07 W=7.6e-07 $X=5250 $Y=590 $dt=3
M22 Y C 4 1 nfet_01v8_lvt L=1.5e-07 W=7.6e-07 $X=5680 $Y=590 $dt=3
M23 4 C Y 1 nfet_01v8_lvt L=1.5e-07 W=7.6e-07 $X=6110 $Y=590 $dt=3
** N=131 EP=8 NDC=24 FDC=24 HDC=24
.ends NAND3X4_HS

* +++++++++++++++++++++++++++++++++++++++++++++++++++++
* Sub cell: AOI21X1_HS
* +++++++++++++++++++++++++++++++++++++++++++++++++++++
.subckt AOI21X1_HS 1 2 VSS Y A0 B0 A1 VDD
M0 8 A0 VDD 2 pfet_01v8 L=1.5e-07 W=1.46e-06 $X=860 $Y=2285 $dt=1
M1 VDD A1 8 2 pfet_01v8 L=1.5e-07 W=1.46e-06 $X=1290 $Y=2285 $dt=1
M2 8 B0 Y 2 pfet_01v8 L=1.5e-07 W=1.46e-06 $X=1720 $Y=2285 $dt=1
M3 VSS A0 10 1 nfet_01v8_lvt L=1.5e-07 W=7.6e-07 $X=860 $Y=395 $dt=3
M4 10 A1 Y 1 nfet_01v8_lvt L=1.5e-07 W=7.6e-07 $X=1290 $Y=395 $dt=3
M5 Y B0 VSS 1 nfet_01v8_lvt L=1.5e-07 W=7.6e-07 $X=1720 $Y=395 $dt=3
** N=47 EP=8 NDC=6 FDC=6 HDC=6
.ends AOI21X1_HS

* +++++++++++++++++++++++++++++++++++++++++++++++++++++
* Sub cell: OAI21X2
* +++++++++++++++++++++++++++++++++++++++++++++++++++++
.subckt OAI21X2 1 2 VSS Y A0 B0 A1 VDD
M0 4 A0 VSS 1 nfet_01v8 L=1.5e-07 W=7.6e-07 $X=400 $Y=590 $dt=0
M1 VSS A0 4 1 nfet_01v8 L=1.5e-07 W=7.6e-07 $X=830 $Y=590 $dt=0
M2 4 B0 Y 1 nfet_01v8 L=1.5e-07 W=7.6e-07 $X=1260 $Y=590 $dt=0
M3 Y B0 4 1 nfet_01v8 L=1.5e-07 W=7.6e-07 $X=1690 $Y=590 $dt=0
M4 4 A1 VSS 1 nfet_01v8 L=1.5e-07 W=7.6e-07 $X=2640 $Y=590 $dt=0
M5 VSS A1 4 1 nfet_01v8 L=1.5e-07 W=7.6e-07 $X=3070 $Y=590 $dt=0
M6 VDD A0 9 2 pfet_01v8 L=1.5e-07 W=1.13e-06 $X=400 $Y=2420 $dt=1
M7 9 A0 VDD 2 pfet_01v8 L=1.5e-07 W=1.13e-06 $X=830 $Y=2420 $dt=1
M8 VDD B0 Y 2 pfet_01v8 L=1.5e-07 W=1.13e-06 $X=1260 $Y=2420 $dt=1
M9 Y B0 VDD 2 pfet_01v8 L=1.5e-07 W=1.13e-06 $X=1690 $Y=2420 $dt=1
M10 Y A1 9 2 pfet_01v8 L=1.5e-07 W=1.13e-06 $X=2640 $Y=2420 $dt=1
M11 9 A1 Y 2 pfet_01v8 L=1.5e-07 W=1.13e-06 $X=3070 $Y=2420 $dt=1
** N=70 EP=8 NDC=12 FDC=12 HDC=12
.ends OAI21X2

* +++++++++++++++++++++++++++++++++++++++++++++++++++++
* Sub cell: OAI22X1_HS
* +++++++++++++++++++++++++++++++++++++++++++++++++++++
.subckt OAI22X1_HS 1 2 VSS Y A0 B1 A1 B0 VDD
M0 VDD A0 11 2 pfet_01v8 L=1.5e-07 W=1.46e-06 $X=860 $Y=2285 $dt=1
M1 11 A1 Y 2 pfet_01v8 L=1.5e-07 W=1.46e-06 $X=1290 $Y=2285 $dt=1
M2 Y B1 12 2 pfet_01v8 L=1.5e-07 W=1.46e-06 $X=1720 $Y=2285 $dt=1
M3 12 B0 VDD 2 pfet_01v8 L=1.5e-07 W=1.46e-06 $X=2150 $Y=2285 $dt=1
M4 4 A0 VSS 1 nfet_01v8_lvt L=1.5e-07 W=7.6e-07 $X=860 $Y=395 $dt=3
M5 VSS A1 4 1 nfet_01v8_lvt L=1.5e-07 W=7.6e-07 $X=1290 $Y=395 $dt=3
M6 4 B1 Y 1 nfet_01v8_lvt L=1.5e-07 W=7.6e-07 $X=1720 $Y=395 $dt=3
M7 Y B0 4 1 nfet_01v8_lvt L=1.5e-07 W=7.6e-07 $X=2150 $Y=395 $dt=3
** N=56 EP=9 NDC=8 FDC=8 HDC=8
.ends OAI22X1_HS

* +++++++++++++++++++++++++++++++++++++++++++++++++++++
* Sub cell: INVX4
* +++++++++++++++++++++++++++++++++++++++++++++++++++++
.subckt INVX4 1 2 VSS Y A VDD
M0 VSS A Y 1 nfet_01v8 L=1.5e-07 W=7.6e-07 $X=400 $Y=590 $dt=0
M1 Y A VSS 1 nfet_01v8 L=1.5e-07 W=7.6e-07 $X=830 $Y=590 $dt=0
M2 VSS A Y 1 nfet_01v8 L=1.5e-07 W=7.6e-07 $X=1260 $Y=590 $dt=0
M3 Y A VSS 1 nfet_01v8 L=1.5e-07 W=7.6e-07 $X=1690 $Y=590 $dt=0
M4 VDD A Y 2 pfet_01v8 L=1.5e-07 W=1.13e-06 $X=400 $Y=2420 $dt=1
M5 Y A VDD 2 pfet_01v8 L=1.5e-07 W=1.13e-06 $X=830 $Y=2420 $dt=1
M6 VDD A Y 2 pfet_01v8 L=1.5e-07 W=1.13e-06 $X=1260 $Y=2420 $dt=1
M7 Y A VDD 2 pfet_01v8 L=1.5e-07 W=1.13e-06 $X=1690 $Y=2420 $dt=1
** N=43 EP=6 NDC=8 FDC=8 HDC=8
.ends INVX4

* +++++++++++++++++++++++++++++++++++++++++++++++++++++
* Sub cell: CLKINVX4_HS
* +++++++++++++++++++++++++++++++++++++++++++++++++++++
.subckt CLKINVX4_HS 1 2 VSS Y A VDD
M0 VDD A Y 2 pfet_01v8 L=1.5e-07 W=1.06e-06 $X=860 $Y=2490 $dt=1
M1 Y A VDD 2 pfet_01v8 L=1.5e-07 W=1.06e-06 $X=1290 $Y=2490 $dt=1
M2 VDD A Y 2 pfet_01v8 L=1.5e-07 W=1.06e-06 $X=1720 $Y=2490 $dt=1
M3 Y A VDD 2 pfet_01v8 L=1.5e-07 W=1.06e-06 $X=2150 $Y=2490 $dt=1
M4 VDD A Y 2 pfet_01v8 L=1.5e-07 W=1.06e-06 $X=2580 $Y=2490 $dt=1
M5 Y A VDD 2 pfet_01v8 L=1.5e-07 W=1.06e-06 $X=3010 $Y=2490 $dt=1
M6 VDD A Y 2 pfet_01v8 L=1.5e-07 W=1.06e-06 $X=3440 $Y=2490 $dt=1
M7 Y A VDD 2 pfet_01v8 L=1.5e-07 W=1.06e-06 $X=3870 $Y=2490 $dt=1
M8 VDD A Y 2 pfet_01v8 L=1.5e-07 W=1.06e-06 $X=4300 $Y=2490 $dt=1
M9 Y A VDD 2 pfet_01v8 L=1.5e-07 W=1.06e-06 $X=4730 $Y=2490 $dt=1
M10 VDD A Y 2 pfet_01v8 L=1.5e-07 W=1.06e-06 $X=5160 $Y=2490 $dt=1
M11 Y A VDD 2 pfet_01v8 L=1.5e-07 W=1.06e-06 $X=5590 $Y=2490 $dt=1
M12 VSS A Y 1 nfet_01v8_lvt L=1.5e-07 W=7.6e-07 $X=860 $Y=590 $dt=3
M13 Y A VSS 1 nfet_01v8_lvt L=1.5e-07 W=7.6e-07 $X=1290 $Y=590 $dt=3
M14 VSS A Y 1 nfet_01v8_lvt L=1.5e-07 W=7.6e-07 $X=1720 $Y=590 $dt=3
M15 Y A VSS 1 nfet_01v8_lvt L=1.5e-07 W=7.6e-07 $X=2150 $Y=590 $dt=3
** N=93 EP=6 NDC=16 FDC=16 HDC=16
.ends CLKINVX4_HS

* +++++++++++++++++++++++++++++++++++++++++++++++++++++
* Sub cell: AOI22X1
* +++++++++++++++++++++++++++++++++++++++++++++++++++++
.subckt AOI22X1 1 2 VSS Y B1 A0 B0 A1 VDD
M0 VSS A0 11 1 nfet_01v8 L=1.5e-07 W=7.6e-07 $X=400 $Y=590 $dt=0
M1 11 A1 Y 1 nfet_01v8 L=1.5e-07 W=7.6e-07 $X=830 $Y=590 $dt=0
M2 Y B1 12 1 nfet_01v8 L=1.5e-07 W=7.6e-07 $X=1260 $Y=590 $dt=0
M3 12 B0 VSS 1 nfet_01v8 L=1.5e-07 W=7.6e-07 $X=1690 $Y=590 $dt=0
M4 9 A0 VDD 2 pfet_01v8 L=1.5e-07 W=1.13e-06 $X=400 $Y=2420 $dt=1
M5 VDD A1 9 2 pfet_01v8 L=1.5e-07 W=1.13e-06 $X=830 $Y=2420 $dt=1
M6 9 B1 Y 2 pfet_01v8 L=1.5e-07 W=1.13e-06 $X=1260 $Y=2420 $dt=1
M7 Y B0 9 2 pfet_01v8 L=1.5e-07 W=1.13e-06 $X=1690 $Y=2420 $dt=1
** N=51 EP=9 NDC=8 FDC=8 HDC=8
.ends AOI22X1

* +++++++++++++++++++++++++++++++++++++++++++++++++++++
* Sub cell: NOR3X1
* +++++++++++++++++++++++++++++++++++++++++++++++++++++
.subckt NOR3X1 1 2 VSS Y A C B VDD
M0 VSS A Y 1 nfet_01v8 L=1.5e-07 W=7.6e-07 $X=400 $Y=590 $dt=0
M1 Y B VSS 1 nfet_01v8 L=1.5e-07 W=7.6e-07 $X=830 $Y=590 $dt=0
M2 VSS C Y 1 nfet_01v8 L=1.5e-07 W=7.6e-07 $X=1260 $Y=590 $dt=0
M3 VDD A 9 2 pfet_01v8 L=1.5e-07 W=1.13e-06 $X=400 $Y=2420 $dt=1
M4 9 B 10 2 pfet_01v8 L=1.5e-07 W=1.13e-06 $X=830 $Y=2420 $dt=1
M5 10 C Y 2 pfet_01v8 L=1.5e-07 W=1.13e-06 $X=1260 $Y=2420 $dt=1
** N=37 EP=8 NDC=6 FDC=6 HDC=6
.ends NOR3X1

* +++++++++++++++++++++++++++++++++++++++++++++++++++++
* Sub cell: NAND2X2
* +++++++++++++++++++++++++++++++++++++++++++++++++++++
.subckt NAND2X2 1 2 VSS Y A B VDD
M0 4 A VSS 1 nfet_01v8 L=1.5e-07 W=7.6e-07 $X=400 $Y=590 $dt=0
M1 VSS A 4 1 nfet_01v8 L=1.5e-07 W=7.6e-07 $X=830 $Y=590 $dt=0
M2 4 B Y 1 nfet_01v8 L=1.5e-07 W=7.6e-07 $X=1260 $Y=590 $dt=0
M3 Y B 4 1 nfet_01v8 L=1.5e-07 W=7.6e-07 $X=1690 $Y=590 $dt=0
M4 VDD A Y 2 pfet_01v8 L=1.5e-07 W=1.13e-06 $X=400 $Y=2420 $dt=1
M5 Y A VDD 2 pfet_01v8 L=1.5e-07 W=1.13e-06 $X=830 $Y=2420 $dt=1
M6 VDD B Y 2 pfet_01v8 L=1.5e-07 W=1.13e-06 $X=1260 $Y=2420 $dt=1
M7 Y B VDD 2 pfet_01v8 L=1.5e-07 W=1.13e-06 $X=1690 $Y=2420 $dt=1
** N=45 EP=7 NDC=8 FDC=8 HDC=8
.ends NAND2X2

* +++++++++++++++++++++++++++++++++++++++++++++++++++++
* Sub cell: NOR4X1
* +++++++++++++++++++++++++++++++++++++++++++++++++++++
.subckt NOR4X1 1 2 VSS Y B D A C VDD
M0 Y A VSS 1 nfet_01v8 L=1.5e-07 W=7.6e-07 $X=400 $Y=590 $dt=0
M1 VSS B Y 1 nfet_01v8 L=1.5e-07 W=7.6e-07 $X=830 $Y=590 $dt=0
M2 Y C VSS 1 nfet_01v8 L=1.5e-07 W=7.6e-07 $X=1260 $Y=590 $dt=0
M3 VSS D Y 1 nfet_01v8 L=1.5e-07 W=7.6e-07 $X=1690 $Y=590 $dt=0
M4 VDD A 10 2 pfet_01v8 L=1.5e-07 W=1.13e-06 $X=400 $Y=2420 $dt=1
M5 10 B 11 2 pfet_01v8 L=1.5e-07 W=1.13e-06 $X=830 $Y=2420 $dt=1
M6 11 C 12 2 pfet_01v8 L=1.5e-07 W=1.13e-06 $X=1260 $Y=2420 $dt=1
M7 12 D Y 2 pfet_01v8 L=1.5e-07 W=1.13e-06 $X=1690 $Y=2420 $dt=1
** N=45 EP=9 NDC=8 FDC=8 HDC=8
.ends NOR4X1

* +++++++++++++++++++++++++++++++++++++++++++++++++++++
* Sub cell: INVX4_HS
* +++++++++++++++++++++++++++++++++++++++++++++++++++++
.subckt INVX4_HS 1 2 VSS Y A VDD
M0 VDD A Y 2 pfet_01v8 L=1.5e-07 W=1.46e-06 $X=860 $Y=2285 $dt=1
M1 Y A VDD 2 pfet_01v8 L=1.5e-07 W=1.46e-06 $X=1290 $Y=2285 $dt=1
M2 VDD A Y 2 pfet_01v8 L=1.5e-07 W=1.46e-06 $X=1720 $Y=2285 $dt=1
M3 Y A VDD 2 pfet_01v8 L=1.5e-07 W=1.46e-06 $X=2150 $Y=2285 $dt=1
M4 VSS A Y 1 nfet_01v8_lvt L=1.5e-07 W=7.6e-07 $X=860 $Y=590 $dt=3
M5 Y A VSS 1 nfet_01v8_lvt L=1.5e-07 W=7.6e-07 $X=1290 $Y=590 $dt=3
M6 VSS A Y 1 nfet_01v8_lvt L=1.5e-07 W=7.6e-07 $X=1720 $Y=590 $dt=3
M7 Y A VSS 1 nfet_01v8_lvt L=1.5e-07 W=7.6e-07 $X=2150 $Y=590 $dt=3
** N=52 EP=6 NDC=8 FDC=8 HDC=8
.ends INVX4_HS

* +++++++++++++++++++++++++++++++++++++++++++++++++++++
* Sub cell: NOR2X1
* +++++++++++++++++++++++++++++++++++++++++++++++++++++
.subckt NOR2X1 1 2 VSS Y B A VDD
M0 VSS A Y 1 nfet_01v8 L=1.5e-07 W=7.6e-07 $X=440 $Y=590 $dt=0
M1 Y B VSS 1 nfet_01v8 L=1.5e-07 W=7.6e-07 $X=910 $Y=590 $dt=0
M2 VDD A 8 2 pfet_01v8 L=1.5e-07 W=1.13e-06 $X=440 $Y=2420 $dt=1
M3 8 B Y 2 pfet_01v8 L=1.5e-07 W=1.13e-06 $X=910 $Y=2420 $dt=1
** N=31 EP=7 NDC=4 FDC=4 HDC=4
.ends NOR2X1

* +++++++++++++++++++++++++++++++++++++++++++++++++++++
* Sub cell: NAND4X2_HS
* +++++++++++++++++++++++++++++++++++++++++++++++++++++
.subckt NAND4X2_HS 1 2 VSS Y A C B D VDD
M0 VDD A Y 2 pfet_01v8 L=1.5e-07 W=1.46e-06 $X=860 $Y=2285 $dt=1
M1 Y A VDD 2 pfet_01v8 L=1.5e-07 W=1.46e-06 $X=1290 $Y=2285 $dt=1
M2 VDD B Y 2 pfet_01v8 L=1.5e-07 W=1.46e-06 $X=1720 $Y=2285 $dt=1
M3 Y B VDD 2 pfet_01v8 L=1.5e-07 W=1.46e-06 $X=2150 $Y=2285 $dt=1
M4 VDD C Y 2 pfet_01v8 L=1.5e-07 W=1.46e-06 $X=3100 $Y=2285 $dt=1
M5 Y C VDD 2 pfet_01v8 L=1.5e-07 W=1.46e-06 $X=3530 $Y=2285 $dt=1
M6 VDD D Y 2 pfet_01v8 L=1.5e-07 W=1.46e-06 $X=3960 $Y=2285 $dt=1
M7 Y D VDD 2 pfet_01v8 L=1.5e-07 W=1.46e-06 $X=4390 $Y=2285 $dt=1
M8 4 A VSS 1 nfet_01v8_lvt L=1.5e-07 W=7.6e-07 $X=860 $Y=395 $dt=3
M9 VSS A 4 1 nfet_01v8_lvt L=1.5e-07 W=7.6e-07 $X=1290 $Y=395 $dt=3
M10 4 B 6 1 nfet_01v8_lvt L=1.5e-07 W=7.6e-07 $X=1720 $Y=395 $dt=3
M11 6 B 4 1 nfet_01v8_lvt L=1.5e-07 W=7.6e-07 $X=2150 $Y=395 $dt=3
M12 5 C 6 1 nfet_01v8_lvt L=1.5e-07 W=7.6e-07 $X=3100 $Y=395 $dt=3
M13 6 C 5 1 nfet_01v8_lvt L=1.5e-07 W=7.6e-07 $X=3530 $Y=395 $dt=3
M14 5 D Y 1 nfet_01v8_lvt L=1.5e-07 W=7.6e-07 $X=3960 $Y=395 $dt=3
M15 Y D 5 1 nfet_01v8_lvt L=1.5e-07 W=7.6e-07 $X=4390 $Y=395 $dt=3
** N=101 EP=9 NDC=16 FDC=16 HDC=16
.ends NAND4X2_HS

* +++++++++++++++++++++++++++++++++++++++++++++++++++++
* Sub cell: OAI211X2_HS
* +++++++++++++++++++++++++++++++++++++++++++++++++++++
.subckt OAI211X2_HS 1 2 VSS Y A0 B0 A1 C0 VDD
M0 11 A0 VDD 2 pfet_01v8 L=1.5e-07 W=1.46e-06 $X=860 $Y=2285 $dt=1
M1 VDD A0 11 2 pfet_01v8 L=1.5e-07 W=1.46e-06 $X=1290 $Y=2285 $dt=1
M2 11 A1 Y 2 pfet_01v8 L=1.5e-07 W=1.46e-06 $X=1720 $Y=2285 $dt=1
M3 Y A1 11 2 pfet_01v8 L=1.5e-07 W=1.46e-06 $X=2150 $Y=2285 $dt=1
M4 VDD B0 Y 2 pfet_01v8 L=1.5e-07 W=1.46e-06 $X=3100 $Y=2285 $dt=1
M5 Y B0 VDD 2 pfet_01v8 L=1.5e-07 W=1.46e-06 $X=3530 $Y=2285 $dt=1
M6 VDD C0 Y 2 pfet_01v8 L=1.5e-07 W=1.46e-06 $X=3960 $Y=2285 $dt=1
M7 Y C0 VDD 2 pfet_01v8 L=1.5e-07 W=1.46e-06 $X=4390 $Y=2285 $dt=1
M8 5 A0 VSS 1 nfet_01v8_lvt L=1.5e-07 W=7.6e-07 $X=860 $Y=395 $dt=3
M9 VSS A0 5 1 nfet_01v8_lvt L=1.5e-07 W=7.6e-07 $X=1290 $Y=395 $dt=3
M10 5 A1 VSS 1 nfet_01v8_lvt L=1.5e-07 W=7.6e-07 $X=1720 $Y=395 $dt=3
M11 VSS A1 5 1 nfet_01v8_lvt L=1.5e-07 W=7.6e-07 $X=2150 $Y=395 $dt=3
M12 4 B0 5 1 nfet_01v8_lvt L=1.5e-07 W=7.6e-07 $X=3100 $Y=395 $dt=3
M13 5 B0 4 1 nfet_01v8_lvt L=1.5e-07 W=7.6e-07 $X=3530 $Y=395 $dt=3
M14 4 C0 Y 1 nfet_01v8_lvt L=1.5e-07 W=7.6e-07 $X=3960 $Y=395 $dt=3
M15 Y C0 4 1 nfet_01v8_lvt L=1.5e-07 W=7.6e-07 $X=4390 $Y=395 $dt=3
** N=102 EP=9 NDC=16 FDC=16 HDC=16
.ends OAI211X2_HS

* +++++++++++++++++++++++++++++++++++++++++++++++++++++
* Sub cell: CLKINVX1_HS
* +++++++++++++++++++++++++++++++++++++++++++++++++++++
.subckt CLKINVX1_HS 1 2 VSS Y A VDD
M0 VDD A Y 2 pfet_01v8 L=1.5e-07 W=1.06e-06 $X=860 $Y=2540 $dt=1
M1 Y A VDD 2 pfet_01v8 L=1.5e-07 W=1.06e-06 $X=1290 $Y=2540 $dt=1
M2 VDD A Y 2 pfet_01v8 L=1.5e-07 W=1.06e-06 $X=1720 $Y=2540 $dt=1
M3 VSS A Y 1 nfet_01v8_lvt L=1.5e-07 W=7.6e-07 $X=860 $Y=590 $dt=3
** N=35 EP=6 NDC=4 FDC=4 HDC=4
.ends CLKINVX1_HS

* +++++++++++++++++++++++++++++++++++++++++++++++++++++
* Sub cell: OAI21X1
* +++++++++++++++++++++++++++++++++++++++++++++++++++++
.subckt OAI21X1 1 2 VSS Y A0 B0 A1 VDD
M0 4 A0 VSS 1 nfet_01v8 L=1.5e-07 W=7.6e-07 $X=400 $Y=590 $dt=0
M1 VSS A1 4 1 nfet_01v8 L=1.5e-07 W=7.6e-07 $X=830 $Y=590 $dt=0
M2 4 B0 Y 1 nfet_01v8 L=1.5e-07 W=7.6e-07 $X=1260 $Y=590 $dt=0
M3 VDD A0 10 2 pfet_01v8 L=1.5e-07 W=1.13e-06 $X=400 $Y=2420 $dt=1
M4 10 A1 Y 2 pfet_01v8 L=1.5e-07 W=1.13e-06 $X=830 $Y=2420 $dt=1
M5 Y B0 VDD 2 pfet_01v8 L=1.5e-07 W=1.13e-06 $X=1260 $Y=2420 $dt=1
** N=41 EP=8 NDC=6 FDC=6 HDC=6
.ends OAI21X1

* +++++++++++++++++++++++++++++++++++++++++++++++++++++
* Sub cell: TIELO
* +++++++++++++++++++++++++++++++++++++++++++++++++++++
.subckt TIELO 1 2 VSS Y VDD
M0 VSS 6 Y 1 nfet_01v8 L=1.5e-07 W=7.6e-07 $X=400 $Y=590 $dt=0
M1 6 6 VDD 2 pfet_01v8 L=1.5e-07 W=1.13e-06 $X=400 $Y=2420 $dt=1
** N=21 EP=5 NDC=2 FDC=2 HDC=2
.ends TIELO

* +++++++++++++++++++++++++++++++++++++++++++++++++++++
* Sub cell: INVX16
* +++++++++++++++++++++++++++++++++++++++++++++++++++++
.subckt INVX16 1 2 VSS Y A VDD
M0 VSS A Y 1 nfet_01v8 L=1.5e-07 W=7.6e-07 $X=400 $Y=590 $dt=0
M1 Y A VSS 1 nfet_01v8 L=1.5e-07 W=7.6e-07 $X=830 $Y=590 $dt=0
M2 VSS A Y 1 nfet_01v8 L=1.5e-07 W=7.6e-07 $X=1260 $Y=590 $dt=0
M3 Y A VSS 1 nfet_01v8 L=1.5e-07 W=7.6e-07 $X=1690 $Y=590 $dt=0
M4 VSS A Y 1 nfet_01v8 L=1.5e-07 W=7.6e-07 $X=2120 $Y=590 $dt=0
M5 Y A VSS 1 nfet_01v8 L=1.5e-07 W=7.6e-07 $X=2550 $Y=590 $dt=0
M6 VSS A Y 1 nfet_01v8 L=1.5e-07 W=7.6e-07 $X=2980 $Y=590 $dt=0
M7 Y A VSS 1 nfet_01v8 L=1.5e-07 W=7.6e-07 $X=3410 $Y=590 $dt=0
M8 VSS A Y 1 nfet_01v8 L=1.5e-07 W=7.6e-07 $X=3840 $Y=590 $dt=0
M9 Y A VSS 1 nfet_01v8 L=1.5e-07 W=7.6e-07 $X=4270 $Y=590 $dt=0
M10 VSS A Y 1 nfet_01v8 L=1.5e-07 W=7.6e-07 $X=4700 $Y=590 $dt=0
M11 Y A VSS 1 nfet_01v8 L=1.5e-07 W=7.6e-07 $X=5130 $Y=590 $dt=0
M12 VSS A Y 1 nfet_01v8 L=1.5e-07 W=7.6e-07 $X=5560 $Y=590 $dt=0
M13 Y A VSS 1 nfet_01v8 L=1.5e-07 W=7.6e-07 $X=5990 $Y=590 $dt=0
M14 VSS A Y 1 nfet_01v8 L=1.5e-07 W=7.6e-07 $X=6420 $Y=590 $dt=0
M15 Y A VSS 1 nfet_01v8 L=1.5e-07 W=7.6e-07 $X=6850 $Y=590 $dt=0
M16 VDD A Y 2 pfet_01v8 L=1.5e-07 W=1.13e-06 $X=400 $Y=2420 $dt=1
M17 Y A VDD 2 pfet_01v8 L=1.5e-07 W=1.13e-06 $X=830 $Y=2420 $dt=1
M18 VDD A Y 2 pfet_01v8 L=1.5e-07 W=1.13e-06 $X=1260 $Y=2420 $dt=1
M19 Y A VDD 2 pfet_01v8 L=1.5e-07 W=1.13e-06 $X=1690 $Y=2420 $dt=1
M20 VDD A Y 2 pfet_01v8 L=1.5e-07 W=1.13e-06 $X=2120 $Y=2420 $dt=1
M21 Y A VDD 2 pfet_01v8 L=1.5e-07 W=1.13e-06 $X=2550 $Y=2420 $dt=1
M22 VDD A Y 2 pfet_01v8 L=1.5e-07 W=1.13e-06 $X=2980 $Y=2420 $dt=1
M23 Y A VDD 2 pfet_01v8 L=1.5e-07 W=1.13e-06 $X=3410 $Y=2420 $dt=1
M24 VDD A Y 2 pfet_01v8 L=1.5e-07 W=1.13e-06 $X=3840 $Y=2420 $dt=1
M25 Y A VDD 2 pfet_01v8 L=1.5e-07 W=1.13e-06 $X=4270 $Y=2420 $dt=1
M26 VDD A Y 2 pfet_01v8 L=1.5e-07 W=1.13e-06 $X=4700 $Y=2420 $dt=1
M27 Y A VDD 2 pfet_01v8 L=1.5e-07 W=1.13e-06 $X=5130 $Y=2420 $dt=1
M28 VDD A Y 2 pfet_01v8 L=1.5e-07 W=1.13e-06 $X=5560 $Y=2420 $dt=1
M29 Y A VDD 2 pfet_01v8 L=1.5e-07 W=1.13e-06 $X=5990 $Y=2420 $dt=1
M30 VDD A Y 2 pfet_01v8 L=1.5e-07 W=1.13e-06 $X=6420 $Y=2420 $dt=1
M31 Y A VDD 2 pfet_01v8 L=1.5e-07 W=1.13e-06 $X=6850 $Y=2420 $dt=1
** N=139 EP=6 NDC=32 FDC=32 HDC=32
.ends INVX16

* +++++++++++++++++++++++++++++++++++++++++++++++++++++
* Sub cell: BUFX2
* +++++++++++++++++++++++++++++++++++++++++++++++++++++
.subckt BUFX2 1 2 VSS Y A VDD
M0 5 A VSS 1 nfet_01v8 L=1.5e-07 W=4.25e-07 $X=400 $Y=590 $dt=0
M1 VSS 5 Y 1 nfet_01v8 L=1.5e-07 W=7.6e-07 $X=890 $Y=590 $dt=0
M2 Y 5 VSS 1 nfet_01v8 L=1.5e-07 W=7.6e-07 $X=1320 $Y=590 $dt=0
M3 VDD A 5 2 pfet_01v8 L=1.5e-07 W=6.25e-07 $X=400 $Y=2925 $dt=1
M4 VDD 5 Y 2 pfet_01v8 L=1.5e-07 W=1.13e-06 $X=890 $Y=2420 $dt=1
M5 Y 5 VDD 2 pfet_01v8 L=1.5e-07 W=1.13e-06 $X=1320 $Y=2420 $dt=1
** N=35 EP=6 NDC=6 FDC=6 HDC=6
.ends BUFX2

* +++++++++++++++++++++++++++++++++++++++++++++++++++++
* Sub cell: INVX1_HS
* +++++++++++++++++++++++++++++++++++++++++++++++++++++
.subckt INVX1_HS 1 2 VSS Y A VDD
M0 VDD A Y 2 pfet_01v8 L=1.5e-07 W=1.46e-06 $X=860 $Y=2285 $dt=1
M1 VSS A Y 1 nfet_01v8_lvt L=1.5e-07 W=7.6e-07 $X=860 $Y=590 $dt=3
** N=25 EP=6 NDC=2 FDC=2 HDC=2
.ends INVX1_HS

* +++++++++++++++++++++++++++++++++++++++++++++++++++++
* Sub cell: BUFX2_HS
* +++++++++++++++++++++++++++++++++++++++++++++++++++++
.subckt BUFX2_HS 1 2 VSS Y A VDD
M0 VDD A 5 2 pfet_01v8 L=1.5e-07 W=7.8e-07 $X=860 $Y=2965 $dt=1
M1 VDD 5 Y 2 pfet_01v8 L=1.5e-07 W=1.46e-06 $X=1350 $Y=2285 $dt=1
M2 Y 5 VDD 2 pfet_01v8 L=1.5e-07 W=1.46e-06 $X=1780 $Y=2285 $dt=1
M3 5 A VSS 1 nfet_01v8_lvt L=1.5e-07 W=4.25e-07 $X=860 $Y=395 $dt=3
M4 VSS 5 Y 1 nfet_01v8_lvt L=1.5e-07 W=7.6e-07 $X=1350 $Y=395 $dt=3
M5 Y 5 VSS 1 nfet_01v8_lvt L=1.5e-07 W=7.6e-07 $X=1780 $Y=395 $dt=3
** N=41 EP=6 NDC=6 FDC=6 HDC=6
.ends BUFX2_HS

* +++++++++++++++++++++++++++++++++++++++++++++++++++++
* Sub cell: CLKBUFX2_HS
* +++++++++++++++++++++++++++++++++++++++++++++++++++++
.subckt CLKBUFX2_HS 1 2 VSS Y A VDD
M0 5 A VDD 2 pfet_01v8 L=1.5e-07 W=1.06e-06 $X=860 $Y=2685 $dt=1
M1 VDD 5 Y 2 pfet_01v8 L=1.5e-07 W=1.06e-06 $X=1290 $Y=2685 $dt=1
M2 Y 5 VDD 2 pfet_01v8 L=1.5e-07 W=1.06e-06 $X=1720 $Y=2685 $dt=1
M3 VDD 5 Y 2 pfet_01v8 L=1.5e-07 W=1.06e-06 $X=2150 $Y=2685 $dt=1
M4 Y 5 VDD 2 pfet_01v8 L=1.5e-07 W=1.06e-06 $X=2580 $Y=2685 $dt=1
M5 5 A VSS 1 nfet_01v8_lvt L=1.5e-07 W=7.6e-07 $X=860 $Y=395 $dt=3
M6 VSS 5 Y 1 nfet_01v8_lvt L=1.5e-07 W=7.6e-07 $X=1290 $Y=395 $dt=3
M7 Y 5 VSS 1 nfet_01v8_lvt L=1.5e-07 W=7.6e-07 $X=1720 $Y=395 $dt=3
** N=50 EP=6 NDC=8 FDC=8 HDC=8
.ends CLKBUFX2_HS

* +++++++++++++++++++++++++++++++++++++++++++++++++++++
* Sub cell: AND4X2_HS
* +++++++++++++++++++++++++++++++++++++++++++++++++++++
.subckt AND4X2_HS 1 2 VSS Y C A D B VDD
M0 VDD D 4 2 pfet_01v8 L=1.5e-07 W=7.8e-07 $X=860 $Y=2965 $dt=1
M1 4 C VDD 2 pfet_01v8 L=1.5e-07 W=7.8e-07 $X=1290 $Y=2965 $dt=1
M2 VDD B 4 2 pfet_01v8 L=1.5e-07 W=7.8e-07 $X=1720 $Y=2965 $dt=1
M3 VDD A 4 2 pfet_01v8 L=1.5e-07 W=7.8e-07 $X=2150 $Y=2965 $dt=1
M4 VDD 4 Y 2 pfet_01v8 L=1.5e-07 W=1.46e-06 $X=2640 $Y=2285 $dt=1
M5 Y 4 VDD 2 pfet_01v8 L=1.5e-07 W=1.46e-06 $X=3070 $Y=2285 $dt=1
M6 4 D 11 1 nfet_01v8_lvt L=1.5e-07 W=4.25e-07 $X=860 $Y=395 $dt=3
M7 11 C 12 1 nfet_01v8_lvt L=1.5e-07 W=4.25e-07 $X=1290 $Y=395 $dt=3
M8 12 B 13 1 nfet_01v8_lvt L=1.5e-07 W=4.25e-07 $X=1720 $Y=395 $dt=3
M9 13 A VSS 1 nfet_01v8_lvt L=1.5e-07 W=4.25e-07 $X=2150 $Y=395 $dt=3
M10 VSS 4 Y 1 nfet_01v8_lvt L=1.5e-07 W=7.6e-07 $X=2640 $Y=395 $dt=3
M11 Y 4 VSS 1 nfet_01v8_lvt L=1.5e-07 W=7.6e-07 $X=3070 $Y=395 $dt=3
** N=65 EP=9 NDC=12 FDC=12 HDC=12
.ends AND4X2_HS

* +++++++++++++++++++++++++++++++++++++++++++++++++++++
* Sub cell: NAND4X4
* +++++++++++++++++++++++++++++++++++++++++++++++++++++
.subckt NAND4X4 1 2 VSS Y A B C D VDD
M0 4 A VSS 1 nfet_01v8 L=1.5e-07 W=7.6e-07 $X=400 $Y=590 $dt=0
M1 VSS A 4 1 nfet_01v8 L=1.5e-07 W=7.6e-07 $X=830 $Y=590 $dt=0
M2 4 A VSS 1 nfet_01v8 L=1.5e-07 W=7.6e-07 $X=1260 $Y=590 $dt=0
M3 VSS A 4 1 nfet_01v8 L=1.5e-07 W=7.6e-07 $X=1690 $Y=590 $dt=0
M4 4 B 6 1 nfet_01v8 L=1.5e-07 W=7.6e-07 $X=2120 $Y=590 $dt=0
M5 6 B 4 1 nfet_01v8 L=1.5e-07 W=7.6e-07 $X=2550 $Y=590 $dt=0
M6 4 B 6 1 nfet_01v8 L=1.5e-07 W=7.6e-07 $X=2980 $Y=590 $dt=0
M7 6 B 4 1 nfet_01v8 L=1.5e-07 W=7.6e-07 $X=3410 $Y=590 $dt=0
M8 5 C 6 1 nfet_01v8 L=1.5e-07 W=7.6e-07 $X=4360 $Y=590 $dt=0
M9 6 C 5 1 nfet_01v8 L=1.5e-07 W=7.6e-07 $X=4790 $Y=590 $dt=0
M10 5 C 6 1 nfet_01v8 L=1.5e-07 W=7.6e-07 $X=5220 $Y=590 $dt=0
M11 6 C 5 1 nfet_01v8 L=1.5e-07 W=7.6e-07 $X=5650 $Y=590 $dt=0
M12 5 D Y 1 nfet_01v8 L=1.5e-07 W=7.6e-07 $X=6080 $Y=590 $dt=0
M13 Y D 5 1 nfet_01v8 L=1.5e-07 W=7.6e-07 $X=6510 $Y=590 $dt=0
M14 5 D Y 1 nfet_01v8 L=1.5e-07 W=7.6e-07 $X=6940 $Y=590 $dt=0
M15 Y D 5 1 nfet_01v8 L=1.5e-07 W=7.6e-07 $X=7370 $Y=590 $dt=0
M16 VDD A Y 2 pfet_01v8 L=1.5e-07 W=1.13e-06 $X=400 $Y=2420 $dt=1
M17 Y A VDD 2 pfet_01v8 L=1.5e-07 W=1.13e-06 $X=830 $Y=2420 $dt=1
M18 VDD A Y 2 pfet_01v8 L=1.5e-07 W=1.13e-06 $X=1260 $Y=2420 $dt=1
M19 Y A VDD 2 pfet_01v8 L=1.5e-07 W=1.13e-06 $X=1690 $Y=2420 $dt=1
M20 VDD B Y 2 pfet_01v8 L=1.5e-07 W=1.13e-06 $X=2120 $Y=2420 $dt=1
M21 Y B VDD 2 pfet_01v8 L=1.5e-07 W=1.13e-06 $X=2550 $Y=2420 $dt=1
M22 VDD B Y 2 pfet_01v8 L=1.5e-07 W=1.13e-06 $X=2980 $Y=2420 $dt=1
M23 Y B VDD 2 pfet_01v8 L=1.5e-07 W=1.13e-06 $X=3410 $Y=2420 $dt=1
M24 VDD C Y 2 pfet_01v8 L=1.5e-07 W=1.13e-06 $X=4360 $Y=2420 $dt=1
M25 Y C VDD 2 pfet_01v8 L=1.5e-07 W=1.13e-06 $X=4790 $Y=2420 $dt=1
M26 VDD C Y 2 pfet_01v8 L=1.5e-07 W=1.13e-06 $X=5220 $Y=2420 $dt=1
M27 Y C VDD 2 pfet_01v8 L=1.5e-07 W=1.13e-06 $X=5650 $Y=2420 $dt=1
M28 VDD D Y 2 pfet_01v8 L=1.5e-07 W=1.13e-06 $X=6080 $Y=2420 $dt=1
M29 Y D VDD 2 pfet_01v8 L=1.5e-07 W=1.13e-06 $X=6510 $Y=2420 $dt=1
M30 VDD D Y 2 pfet_01v8 L=1.5e-07 W=1.13e-06 $X=6940 $Y=2420 $dt=1
M31 Y D VDD 2 pfet_01v8 L=1.5e-07 W=1.13e-06 $X=7370 $Y=2420 $dt=1
** N=148 EP=9 NDC=32 FDC=32 HDC=32
.ends NAND4X4

* +++++++++++++++++++++++++++++++++++++++++++++++++++++
* Sub cell: CLKAND2X2
* +++++++++++++++++++++++++++++++++++++++++++++++++++++
.subckt CLKAND2X2 1 2 VSS Y A B VDD
M0 5 B 9 1 nfet_01v8 L=1.5e-07 W=8.5e-07 $X=400 $Y=590 $dt=0
M1 9 A VSS 1 nfet_01v8 L=1.5e-07 W=8.5e-07 $X=830 $Y=590 $dt=0
M2 VSS 5 Y 1 nfet_01v8 L=1.5e-07 W=7.6e-07 $X=1320 $Y=590 $dt=0
M3 Y 5 VSS 1 nfet_01v8 L=1.5e-07 W=7.6e-07 $X=1750 $Y=590 $dt=0
M4 VDD B 5 2 pfet_01v8 L=1.5e-07 W=6.25e-07 $X=400 $Y=2925 $dt=1
M5 VDD A 5 2 pfet_01v8 L=1.5e-07 W=6.25e-07 $X=830 $Y=2925 $dt=1
M6 VDD 5 Y 2 pfet_01v8 L=1.5e-07 W=1.13e-06 $X=1320 $Y=2420 $dt=1
M7 Y 5 VDD 2 pfet_01v8 L=1.5e-07 W=1.13e-06 $X=1750 $Y=2420 $dt=1
** N=42 EP=7 NDC=8 FDC=8 HDC=8
.ends CLKAND2X2

* +++++++++++++++++++++++++++++++++++++++++++++++++++++
* Sub cell: ICGPRECX1
* +++++++++++++++++++++++++++++++++++++++++++++++++++++
.subckt ICGPRECX1 1 2 VSS ECK TE CK E VDD
M0 VSS TE 4 1 nfet_01v8 L=1.5e-07 W=4.25e-07 $X=400 $Y=590 $dt=0
M1 4 E VSS 1 nfet_01v8 L=1.5e-07 W=4.25e-07 $X=830 $Y=590 $dt=0
M2 VSS 4 5 1 nfet_01v8 L=1.5e-07 W=7.6e-07 $X=1320 $Y=590 $dt=0
M3 8 CK VSS 1 nfet_01v8 L=1.5e-07 W=4.25e-07 $X=2700 $Y=590 $dt=0
M4 VSS 5 19 1 nfet_01v8 L=1.5e-07 W=4.25e-07 $X=3130 $Y=590 $dt=0
M5 19 13 9 1 nfet_01v8 L=1.5e-07 W=4.25e-07 $X=3560 $Y=590 $dt=0
M6 9 8 20 1 nfet_01v8 L=1.5e-07 W=4.25e-07 $X=3990 $Y=590 $dt=0
M7 20 10 VSS 1 nfet_01v8 L=1.5e-07 W=4.25e-07 $X=4420 $Y=590 $dt=0
M8 VSS 8 13 1 nfet_01v8 L=1.5e-07 W=4.25e-07 $X=4850 $Y=590 $dt=0
M9 VSS 9 10 1 nfet_01v8 L=1.5e-07 W=4.25e-07 $X=5840 $Y=590 $dt=0
M10 7 10 21 1 nfet_01v8 L=1.5e-07 W=4.25e-07 $X=7040 $Y=590 $dt=0
M11 21 13 VSS 1 nfet_01v8 L=1.5e-07 W=4.25e-07 $X=7470 $Y=590 $dt=0
M12 VSS 7 ECK 1 nfet_01v8 L=1.5e-07 W=7.6e-07 $X=7945 $Y=590 $dt=0
M13 4 TE 16 2 pfet_01v8 L=1.5e-07 W=6.25e-07 $X=400 $Y=2925 $dt=1
M14 VDD E 16 2 pfet_01v8 L=1.5e-07 W=6.25e-07 $X=830 $Y=2925 $dt=1
M15 VDD 4 5 2 pfet_01v8 L=1.5e-07 W=1.13e-06 $X=1320 $Y=2420 $dt=1
M16 8 CK VDD 2 pfet_01v8 L=1.5e-07 W=6.25e-07 $X=2700 $Y=2925 $dt=1
M17 VDD 5 17 2 pfet_01v8 L=1.5e-07 W=6.25e-07 $X=3130 $Y=2925 $dt=1
M18 17 8 9 2 pfet_01v8 L=1.5e-07 W=6.25e-07 $X=3560 $Y=2925 $dt=1
M19 9 13 18 2 pfet_01v8 L=1.5e-07 W=6.25e-07 $X=3990 $Y=2925 $dt=1
M20 18 10 VDD 2 pfet_01v8 L=1.5e-07 W=6.25e-07 $X=4420 $Y=2925 $dt=1
M21 VDD 8 13 2 pfet_01v8 L=1.5e-07 W=6.25e-07 $X=4850 $Y=2925 $dt=1
M22 VDD 9 10 2 pfet_01v8 L=1.5e-07 W=6.25e-07 $X=5840 $Y=2925 $dt=1
M23 VDD 10 7 2 pfet_01v8 L=1.5e-07 W=6.25e-07 $X=7110 $Y=2925 $dt=1
M24 VDD 13 7 2 pfet_01v8 L=1.5e-07 W=6.25e-07 $X=7540 $Y=2925 $dt=1
M25 VDD 7 ECK 2 pfet_01v8 L=1.5e-07 W=1.13e-06 $X=8015 $Y=2420 $dt=1
** N=112 EP=8 NDC=26 FDC=26 HDC=26
.ends ICGPRECX1

* +++++++++++++++++++++++++++++++++++++++++++++++++++++
* Sub cell: CLKINVX2_HS
* +++++++++++++++++++++++++++++++++++++++++++++++++++++
.subckt CLKINVX2_HS 1 2 VSS Y A VDD
M0 VDD A Y 2 pfet_01v8 L=1.5e-07 W=1.06e-06 $X=860 $Y=2490 $dt=1
M1 Y A VDD 2 pfet_01v8 L=1.5e-07 W=1.06e-06 $X=1290 $Y=2490 $dt=1
M2 VDD A Y 2 pfet_01v8 L=1.5e-07 W=1.06e-06 $X=1720 $Y=2490 $dt=1
M3 Y A VDD 2 pfet_01v8 L=1.5e-07 W=1.06e-06 $X=2150 $Y=2490 $dt=1
M4 VDD A Y 2 pfet_01v8 L=1.5e-07 W=1.06e-06 $X=2580 $Y=2490 $dt=1
M5 Y A VDD 2 pfet_01v8 L=1.5e-07 W=1.06e-06 $X=3010 $Y=2490 $dt=1
M6 VSS A Y 1 nfet_01v8_lvt L=1.5e-07 W=7.6e-07 $X=860 $Y=590 $dt=3
M7 Y A VSS 1 nfet_01v8_lvt L=1.5e-07 W=7.6e-07 $X=1290 $Y=590 $dt=3
** N=53 EP=6 NDC=8 FDC=8 HDC=8
.ends CLKINVX2_HS

* +++++++++++++++++++++++++++++++++++++++++++++++++++++
* Sub cell: NAND2X1
* +++++++++++++++++++++++++++++++++++++++++++++++++++++
.subckt NAND2X1 1 2 VSS Y A B VDD
M0 VSS A 8 1 nfet_01v8 L=1.5e-07 W=7.6e-07 $X=400 $Y=590 $dt=0
M1 8 B Y 1 nfet_01v8 L=1.5e-07 W=7.6e-07 $X=830 $Y=590 $dt=0
M2 VDD A Y 2 pfet_01v8 L=1.5e-07 W=1.13e-06 $X=400 $Y=2420 $dt=1
M3 Y B VDD 2 pfet_01v8 L=1.5e-07 W=1.13e-06 $X=830 $Y=2420 $dt=1
** N=31 EP=7 NDC=4 FDC=4 HDC=4
.ends NAND2X1

* +++++++++++++++++++++++++++++++++++++++++++++++++++++
* Sub cell: CLKINVX1
* +++++++++++++++++++++++++++++++++++++++++++++++++++++
.subckt CLKINVX1 1 2 VSS Y A VDD
M0 VSS A Y 1 nfet_01v8 L=1.5e-07 W=7.6e-07 $X=400 $Y=590 $dt=0
M1 VDD A Y 2 pfet_01v8 L=1.5e-07 W=1.13e-06 $X=400 $Y=2420 $dt=1
** N=21 EP=6 NDC=2 FDC=2 HDC=2
.ends CLKINVX1

* +++++++++++++++++++++++++++++++++++++++++++++++++++++
* Sub cell: XNOR2X1
* +++++++++++++++++++++++++++++++++++++++++++++++++++++
.subckt XNOR2X1 1 2 VSS Y B A VDD
M0 4 B VSS 1 nfet_01v8 L=1.5e-07 W=4.25e-07 $X=400 $Y=590 $dt=0
M1 VSS A 7 1 nfet_01v8 L=1.5e-07 W=4.25e-07 $X=830 $Y=590 $dt=0
M2 7 B 5 1 nfet_01v8 L=1.5e-07 W=4.25e-07 $X=1260 $Y=590 $dt=0
M3 5 4 12 1 nfet_01v8 L=1.5e-07 W=4.25e-07 $X=1690 $Y=590 $dt=0
M4 12 7 VSS 1 nfet_01v8 L=1.5e-07 W=4.25e-07 $X=2120 $Y=590 $dt=0
M5 VSS 5 Y 1 nfet_01v8 L=1.5e-07 W=7.6e-07 $X=2610 $Y=590 $dt=0
M6 4 B VDD 2 pfet_01v8 L=1.5e-07 W=6.25e-07 $X=400 $Y=2925 $dt=1
M7 VDD A 7 2 pfet_01v8 L=1.5e-07 W=6.25e-07 $X=830 $Y=2925 $dt=1
M8 7 4 5 2 pfet_01v8 L=1.5e-07 W=6.25e-07 $X=1260 $Y=2925 $dt=1
M9 5 B 11 2 pfet_01v8 L=1.5e-07 W=6.25e-07 $X=1690 $Y=2925 $dt=1
M10 VDD 7 11 2 pfet_01v8 L=1.5e-07 W=6.25e-07 $X=2120 $Y=2925 $dt=1
M11 VDD 5 Y 2 pfet_01v8 L=1.5e-07 W=1.13e-06 $X=2610 $Y=2420 $dt=1
** N=53 EP=7 NDC=12 FDC=12 HDC=12
.ends XNOR2X1

* +++++++++++++++++++++++++++++++++++++++++++++++++++++
* Sub cell: NOR2X4_HS
* +++++++++++++++++++++++++++++++++++++++++++++++++++++
.subckt NOR2X4_HS 1 2 VSS Y A B VDD
M0 7 A VDD 2 pfet_01v8 L=1.5e-07 W=1.46e-06 $X=860 $Y=2285 $dt=1
M1 VDD A 7 2 pfet_01v8 L=1.5e-07 W=1.46e-06 $X=1290 $Y=2285 $dt=1
M2 7 A VDD 2 pfet_01v8 L=1.5e-07 W=1.46e-06 $X=1720 $Y=2285 $dt=1
M3 VDD A 7 2 pfet_01v8 L=1.5e-07 W=1.46e-06 $X=2150 $Y=2285 $dt=1
M4 7 B Y 2 pfet_01v8 L=1.5e-07 W=1.46e-06 $X=2580 $Y=2285 $dt=1
M5 Y B 7 2 pfet_01v8 L=1.5e-07 W=1.46e-06 $X=3010 $Y=2285 $dt=1
M6 7 B Y 2 pfet_01v8 L=1.5e-07 W=1.46e-06 $X=3440 $Y=2285 $dt=1
M7 Y B 7 2 pfet_01v8 L=1.5e-07 W=1.46e-06 $X=3870 $Y=2285 $dt=1
M8 VSS A Y 1 nfet_01v8_lvt L=1.5e-07 W=7.6e-07 $X=860 $Y=395 $dt=3
M9 Y A VSS 1 nfet_01v8_lvt L=1.5e-07 W=7.6e-07 $X=1290 $Y=395 $dt=3
M10 VSS A Y 1 nfet_01v8_lvt L=1.5e-07 W=7.6e-07 $X=1720 $Y=395 $dt=3
M11 Y A VSS 1 nfet_01v8_lvt L=1.5e-07 W=7.6e-07 $X=2150 $Y=395 $dt=3
M12 VSS B Y 1 nfet_01v8_lvt L=1.5e-07 W=7.6e-07 $X=2580 $Y=395 $dt=3
M13 Y B VSS 1 nfet_01v8_lvt L=1.5e-07 W=7.6e-07 $X=3010 $Y=395 $dt=3
M14 VSS B Y 1 nfet_01v8_lvt L=1.5e-07 W=7.6e-07 $X=3440 $Y=395 $dt=3
M15 Y B VSS 1 nfet_01v8_lvt L=1.5e-07 W=7.6e-07 $X=3870 $Y=395 $dt=3
** N=90 EP=7 NDC=16 FDC=16 HDC=16
.ends NOR2X4_HS

* +++++++++++++++++++++++++++++++++++++++++++++++++++++
* Sub cell: NAND4X1
* +++++++++++++++++++++++++++++++++++++++++++++++++++++
.subckt NAND4X1 1 2 VSS Y B D A C VDD
M0 VSS A 10 1 nfet_01v8 L=1.5e-07 W=7.6e-07 $X=400 $Y=590 $dt=0
M1 10 B 11 1 nfet_01v8 L=1.5e-07 W=7.6e-07 $X=830 $Y=590 $dt=0
M2 11 C 12 1 nfet_01v8 L=1.5e-07 W=7.6e-07 $X=1260 $Y=590 $dt=0
M3 12 D Y 1 nfet_01v8 L=1.5e-07 W=7.6e-07 $X=1690 $Y=590 $dt=0
M4 VDD A Y 2 pfet_01v8 L=1.5e-07 W=1.13e-06 $X=400 $Y=2420 $dt=1
M5 Y B VDD 2 pfet_01v8 L=1.5e-07 W=1.13e-06 $X=830 $Y=2420 $dt=1
M6 VDD C Y 2 pfet_01v8 L=1.5e-07 W=1.13e-06 $X=1260 $Y=2420 $dt=1
M7 Y D VDD 2 pfet_01v8 L=1.5e-07 W=1.13e-06 $X=1690 $Y=2420 $dt=1
** N=51 EP=9 NDC=8 FDC=8 HDC=8
.ends NAND4X1

* +++++++++++++++++++++++++++++++++++++++++++++++++++++
* Sub cell: OR2X1_HS
* +++++++++++++++++++++++++++++++++++++++++++++++++++++
.subckt OR2X1_HS 1 2 VSS Y B A VDD
M0 4 B 9 2 pfet_01v8 L=1.5e-07 W=7.8e-07 $X=860 $Y=2965 $dt=1
M1 VDD A 9 2 pfet_01v8 L=1.5e-07 W=7.8e-07 $X=1290 $Y=2965 $dt=1
M2 VDD 4 Y 2 pfet_01v8 L=1.5e-07 W=1.46e-06 $X=1780 $Y=2285 $dt=1
M3 VSS B 4 1 nfet_01v8_lvt L=1.5e-07 W=4.25e-07 $X=860 $Y=395 $dt=3
M4 4 A VSS 1 nfet_01v8_lvt L=1.5e-07 W=4.25e-07 $X=1290 $Y=395 $dt=3
M5 VSS 4 Y 1 nfet_01v8_lvt L=1.5e-07 W=7.6e-07 $X=1780 $Y=395 $dt=3
** N=39 EP=7 NDC=6 FDC=6 HDC=6
.ends OR2X1_HS

* +++++++++++++++++++++++++++++++++++++++++++++++++++++
* Sub cell: INVX2
* +++++++++++++++++++++++++++++++++++++++++++++++++++++
.subckt INVX2 1 2 VSS Y A VDD
M0 VSS A Y 1 nfet_01v8 L=1.5e-07 W=7.6e-07 $X=400 $Y=590 $dt=0
M1 Y A VSS 1 nfet_01v8 L=1.5e-07 W=7.6e-07 $X=830 $Y=590 $dt=0
M2 VDD A Y 2 pfet_01v8 L=1.5e-07 W=1.13e-06 $X=400 $Y=2420 $dt=1
M3 Y A VDD 2 pfet_01v8 L=1.5e-07 W=1.13e-06 $X=830 $Y=2420 $dt=1
** N=27 EP=6 NDC=4 FDC=4 HDC=4
.ends INVX2

* +++++++++++++++++++++++++++++++++++++++++++++++++++++
* Sub cell: AOI211X1_HS
* +++++++++++++++++++++++++++++++++++++++++++++++++++++
.subckt AOI211X1_HS 1 2 VSS Y A0 C0 A1 B0 VDD
M0 9 A1 VDD 2 pfet_01v8 L=1.5e-07 W=1.46e-06 $X=860 $Y=2285 $dt=1
M1 VDD A0 9 2 pfet_01v8 L=1.5e-07 W=1.46e-06 $X=1290 $Y=2285 $dt=1
M2 9 B0 11 2 pfet_01v8 L=1.5e-07 W=1.46e-06 $X=1720 $Y=2285 $dt=1
M3 11 C0 Y 2 pfet_01v8 L=1.5e-07 W=1.46e-06 $X=2150 $Y=2285 $dt=1
M4 Y A1 12 1 nfet_01v8_lvt L=1.5e-07 W=7.6e-07 $X=860 $Y=395 $dt=3
M5 12 A0 VSS 1 nfet_01v8_lvt L=1.5e-07 W=7.6e-07 $X=1290 $Y=395 $dt=3
M6 VSS B0 Y 1 nfet_01v8_lvt L=1.5e-07 W=7.6e-07 $X=1720 $Y=395 $dt=3
M7 Y C0 VSS 1 nfet_01v8_lvt L=1.5e-07 W=7.6e-07 $X=2150 $Y=395 $dt=3
** N=57 EP=9 NDC=8 FDC=8 HDC=8
.ends AOI211X1_HS

* +++++++++++++++++++++++++++++++++++++++++++++++++++++
* Sub cell: BUFX8
* +++++++++++++++++++++++++++++++++++++++++++++++++++++
.subckt BUFX8 1 2 VSS Y A VDD
M0 VSS A 4 1 nfet_01v8 L=1.5e-07 W=7.6e-07 $X=400 $Y=590 $dt=0
M1 4 A VSS 1 nfet_01v8 L=1.5e-07 W=7.6e-07 $X=830 $Y=590 $dt=0
M2 VSS 4 Y 1 nfet_01v8 L=1.5e-07 W=7.6e-07 $X=1260 $Y=590 $dt=0
M3 Y 4 VSS 1 nfet_01v8 L=1.5e-07 W=7.6e-07 $X=1690 $Y=590 $dt=0
M4 VSS 4 Y 1 nfet_01v8 L=1.5e-07 W=7.6e-07 $X=2120 $Y=590 $dt=0
M5 Y 4 VSS 1 nfet_01v8 L=1.5e-07 W=7.6e-07 $X=2550 $Y=590 $dt=0
M6 VSS 4 Y 1 nfet_01v8 L=1.5e-07 W=7.6e-07 $X=2980 $Y=590 $dt=0
M7 Y 4 VSS 1 nfet_01v8 L=1.5e-07 W=7.6e-07 $X=3410 $Y=590 $dt=0
M8 VSS 4 Y 1 nfet_01v8 L=1.5e-07 W=7.6e-07 $X=3840 $Y=590 $dt=0
M9 Y 4 VSS 1 nfet_01v8 L=1.5e-07 W=7.6e-07 $X=4270 $Y=590 $dt=0
M10 VDD A 4 2 pfet_01v8 L=1.5e-07 W=1.13e-06 $X=400 $Y=2420 $dt=1
M11 4 A VDD 2 pfet_01v8 L=1.5e-07 W=1.13e-06 $X=830 $Y=2420 $dt=1
M12 VDD 4 Y 2 pfet_01v8 L=1.5e-07 W=1.13e-06 $X=1260 $Y=2420 $dt=1
M13 Y 4 VDD 2 pfet_01v8 L=1.5e-07 W=1.13e-06 $X=1690 $Y=2420 $dt=1
M14 VDD 4 Y 2 pfet_01v8 L=1.5e-07 W=1.13e-06 $X=2120 $Y=2420 $dt=1
M15 Y 4 VDD 2 pfet_01v8 L=1.5e-07 W=1.13e-06 $X=2550 $Y=2420 $dt=1
M16 VDD 4 Y 2 pfet_01v8 L=1.5e-07 W=1.13e-06 $X=2980 $Y=2420 $dt=1
M17 Y 4 VDD 2 pfet_01v8 L=1.5e-07 W=1.13e-06 $X=3410 $Y=2420 $dt=1
M18 VDD 4 Y 2 pfet_01v8 L=1.5e-07 W=1.13e-06 $X=3840 $Y=2420 $dt=1
M19 Y 4 VDD 2 pfet_01v8 L=1.5e-07 W=1.13e-06 $X=4270 $Y=2420 $dt=1
** N=91 EP=6 NDC=20 FDC=20 HDC=20
.ends BUFX8

* +++++++++++++++++++++++++++++++++++++++++++++++++++++
* Sub cell: NOR3X1_HS
* +++++++++++++++++++++++++++++++++++++++++++++++++++++
.subckt NOR3X1_HS 1 2 VSS Y A C B VDD
M0 VDD A 9 2 pfet_01v8 L=1.5e-07 W=1.46e-06 $X=860 $Y=2285 $dt=1
M1 9 B 10 2 pfet_01v8 L=1.5e-07 W=1.46e-06 $X=1290 $Y=2285 $dt=1
M2 10 C Y 2 pfet_01v8 L=1.5e-07 W=1.46e-06 $X=1720 $Y=2285 $dt=1
M3 VSS A Y 1 nfet_01v8_lvt L=1.5e-07 W=7.6e-07 $X=860 $Y=395 $dt=3
M4 Y B VSS 1 nfet_01v8_lvt L=1.5e-07 W=7.6e-07 $X=1290 $Y=395 $dt=3
M5 VSS C Y 1 nfet_01v8_lvt L=1.5e-07 W=7.6e-07 $X=1720 $Y=395 $dt=3
** N=41 EP=8 NDC=6 FDC=6 HDC=6
.ends NOR3X1_HS

* +++++++++++++++++++++++++++++++++++++++++++++++++++++
* Sub cell: CLKINVX8
* +++++++++++++++++++++++++++++++++++++++++++++++++++++
.subckt CLKINVX8 1 2 VSS Y A VDD
M0 VSS A Y 1 nfet_01v8 L=1.5e-07 W=7.6e-07 $X=400 $Y=590 $dt=0
M1 Y A VSS 1 nfet_01v8 L=1.5e-07 W=7.6e-07 $X=830 $Y=590 $dt=0
M2 VSS A Y 1 nfet_01v8 L=1.5e-07 W=7.6e-07 $X=1260 $Y=590 $dt=0
M3 Y A VSS 1 nfet_01v8 L=1.5e-07 W=7.6e-07 $X=1690 $Y=590 $dt=0
M4 VSS A Y 1 nfet_01v8 L=1.5e-07 W=7.6e-07 $X=2120 $Y=590 $dt=0
M5 Y A VSS 1 nfet_01v8 L=1.5e-07 W=7.6e-07 $X=2550 $Y=590 $dt=0
M6 VSS A Y 1 nfet_01v8 L=1.5e-07 W=7.6e-07 $X=2980 $Y=590 $dt=0
M7 Y A VSS 1 nfet_01v8 L=1.5e-07 W=7.6e-07 $X=3410 $Y=590 $dt=0
M8 VDD A Y 2 pfet_01v8 L=1.5e-07 W=1.13e-06 $X=400 $Y=2420 $dt=1
M9 Y A VDD 2 pfet_01v8 L=1.5e-07 W=1.13e-06 $X=830 $Y=2420 $dt=1
M10 VDD A Y 2 pfet_01v8 L=1.5e-07 W=1.13e-06 $X=1260 $Y=2420 $dt=1
M11 Y A VDD 2 pfet_01v8 L=1.5e-07 W=1.13e-06 $X=1690 $Y=2420 $dt=1
M12 VDD A Y 2 pfet_01v8 L=1.5e-07 W=1.13e-06 $X=2120 $Y=2420 $dt=1
M13 Y A VDD 2 pfet_01v8 L=1.5e-07 W=1.13e-06 $X=2550 $Y=2420 $dt=1
M14 VDD A Y 2 pfet_01v8 L=1.5e-07 W=1.13e-06 $X=2980 $Y=2420 $dt=1
M15 Y A VDD 2 pfet_01v8 L=1.5e-07 W=1.13e-06 $X=3410 $Y=2420 $dt=1
** N=74 EP=6 NDC=16 FDC=16 HDC=16
.ends CLKINVX8

* +++++++++++++++++++++++++++++++++++++++++++++++++++++
* Sub cell: CLKBUFX8
* +++++++++++++++++++++++++++++++++++++++++++++++++++++
.subckt CLKBUFX8 1 2 VSS Y A VDD
M0 VSS A 4 1 nfet_01v8 L=1.5e-07 W=7.6e-07 $X=400 $Y=590 $dt=0
M1 4 A VSS 1 nfet_01v8 L=1.5e-07 W=7.6e-07 $X=830 $Y=590 $dt=0
M2 VSS 4 Y 1 nfet_01v8 L=1.5e-07 W=7.6e-07 $X=1260 $Y=590 $dt=0
M3 Y 4 VSS 1 nfet_01v8 L=1.5e-07 W=7.6e-07 $X=1690 $Y=590 $dt=0
M4 VSS 4 Y 1 nfet_01v8 L=1.5e-07 W=7.6e-07 $X=2120 $Y=590 $dt=0
M5 Y 4 VSS 1 nfet_01v8 L=1.5e-07 W=7.6e-07 $X=2550 $Y=590 $dt=0
M6 VSS 4 Y 1 nfet_01v8 L=1.5e-07 W=7.6e-07 $X=2980 $Y=590 $dt=0
M7 Y 4 VSS 1 nfet_01v8 L=1.5e-07 W=7.6e-07 $X=3410 $Y=590 $dt=0
M8 VSS 4 Y 1 nfet_01v8 L=1.5e-07 W=7.6e-07 $X=3840 $Y=590 $dt=0
M9 Y 4 VSS 1 nfet_01v8 L=1.5e-07 W=7.6e-07 $X=4270 $Y=590 $dt=0
M10 VDD A 4 2 pfet_01v8 L=1.5e-07 W=1.13e-06 $X=400 $Y=2420 $dt=1
M11 4 A VDD 2 pfet_01v8 L=1.5e-07 W=1.13e-06 $X=830 $Y=2420 $dt=1
M12 VDD 4 Y 2 pfet_01v8 L=1.5e-07 W=1.13e-06 $X=1260 $Y=2420 $dt=1
M13 Y 4 VDD 2 pfet_01v8 L=1.5e-07 W=1.13e-06 $X=1690 $Y=2420 $dt=1
M14 VDD 4 Y 2 pfet_01v8 L=1.5e-07 W=1.13e-06 $X=2120 $Y=2420 $dt=1
M15 Y 4 VDD 2 pfet_01v8 L=1.5e-07 W=1.13e-06 $X=2550 $Y=2420 $dt=1
M16 VDD 4 Y 2 pfet_01v8 L=1.5e-07 W=1.13e-06 $X=2980 $Y=2420 $dt=1
M17 Y 4 VDD 2 pfet_01v8 L=1.5e-07 W=1.13e-06 $X=3410 $Y=2420 $dt=1
M18 VDD 4 Y 2 pfet_01v8 L=1.5e-07 W=1.13e-06 $X=3840 $Y=2420 $dt=1
M19 Y 4 VDD 2 pfet_01v8 L=1.5e-07 W=1.13e-06 $X=4270 $Y=2420 $dt=1
** N=92 EP=6 NDC=20 FDC=20 HDC=20
.ends CLKBUFX8

* +++++++++++++++++++++++++++++++++++++++++++++++++++++
* Sub cell: AND2X1_HS
* +++++++++++++++++++++++++++++++++++++++++++++++++++++
.subckt AND2X1_HS 1 2 VSS Y B A VDD
M0 VDD A 5 2 pfet_01v8 L=1.5e-07 W=7.8e-07 $X=860 $Y=2965 $dt=1
M1 VDD B 5 2 pfet_01v8 L=1.5e-07 W=7.8e-07 $X=1290 $Y=2965 $dt=1
M2 VDD 5 Y 2 pfet_01v8 L=1.5e-07 W=1.46e-06 $X=1780 $Y=2285 $dt=1
M3 5 A 9 1 nfet_01v8_lvt L=1.5e-07 W=4.25e-07 $X=860 $Y=395 $dt=3
M4 9 B VSS 1 nfet_01v8_lvt L=1.5e-07 W=4.25e-07 $X=1290 $Y=395 $dt=3
M5 VSS 5 Y 1 nfet_01v8_lvt L=1.5e-07 W=7.6e-07 $X=1780 $Y=395 $dt=3
** N=40 EP=7 NDC=6 FDC=6 HDC=6
.ends AND2X1_HS

* +++++++++++++++++++++++++++++++++++++++++++++++++++++
* Sub cell: OAI22X2_HS
* +++++++++++++++++++++++++++++++++++++++++++++++++++++
.subckt OAI22X2_HS 1 2 VSS Y A0 A1 B1 B0 VDD
M0 VDD A0 11 2 pfet_01v8 L=1.5e-07 W=1.46e-06 $X=860 $Y=2285 $dt=1
M1 11 A0 VDD 2 pfet_01v8 L=1.5e-07 W=1.46e-06 $X=1290 $Y=2285 $dt=1
M2 VDD B0 10 2 pfet_01v8 L=1.5e-07 W=1.46e-06 $X=1720 $Y=2285 $dt=1
M3 10 B0 VDD 2 pfet_01v8 L=1.5e-07 W=1.46e-06 $X=2150 $Y=2285 $dt=1
M4 Y A1 11 2 pfet_01v8 L=1.5e-07 W=1.46e-06 $X=3100 $Y=2285 $dt=1
M5 11 A1 Y 2 pfet_01v8 L=1.5e-07 W=1.46e-06 $X=3530 $Y=2285 $dt=1
M6 Y B1 10 2 pfet_01v8 L=1.5e-07 W=1.46e-06 $X=3960 $Y=2285 $dt=1
M7 10 B1 Y 2 pfet_01v8 L=1.5e-07 W=1.46e-06 $X=4390 $Y=2285 $dt=1
M8 4 A0 VSS 1 nfet_01v8_lvt L=1.5e-07 W=7.6e-07 $X=860 $Y=395 $dt=3
M9 VSS A0 4 1 nfet_01v8_lvt L=1.5e-07 W=7.6e-07 $X=1290 $Y=395 $dt=3
M10 4 B0 Y 1 nfet_01v8_lvt L=1.5e-07 W=7.6e-07 $X=1720 $Y=395 $dt=3
M11 Y B0 4 1 nfet_01v8_lvt L=1.5e-07 W=7.6e-07 $X=2150 $Y=395 $dt=3
M12 4 A1 VSS 1 nfet_01v8_lvt L=1.5e-07 W=7.6e-07 $X=3100 $Y=395 $dt=3
M13 VSS A1 4 1 nfet_01v8_lvt L=1.5e-07 W=7.6e-07 $X=3530 $Y=395 $dt=3
M14 4 B1 Y 1 nfet_01v8_lvt L=1.5e-07 W=7.6e-07 $X=3960 $Y=395 $dt=3
M15 Y B1 4 1 nfet_01v8_lvt L=1.5e-07 W=7.6e-07 $X=4390 $Y=395 $dt=3
** N=102 EP=9 NDC=16 FDC=16 HDC=16
.ends OAI22X2_HS

* +++++++++++++++++++++++++++++++++++++++++++++++++++++
* Sub cell: NAND2X1_HS
* +++++++++++++++++++++++++++++++++++++++++++++++++++++
.subckt NAND2X1_HS 1 2 VSS Y A B VDD
M0 VDD A Y 2 pfet_01v8 L=1.5e-07 W=1.46e-06 $X=860 $Y=2285 $dt=1
M1 Y B VDD 2 pfet_01v8 L=1.5e-07 W=1.46e-06 $X=1290 $Y=2285 $dt=1
M2 VSS A 8 1 nfet_01v8_lvt L=1.5e-07 W=7.6e-07 $X=860 $Y=395 $dt=3
M3 8 B Y 1 nfet_01v8_lvt L=1.5e-07 W=7.6e-07 $X=1290 $Y=395 $dt=3
** N=36 EP=7 NDC=4 FDC=4 HDC=4
.ends NAND2X1_HS

* +++++++++++++++++++++++++++++++++++++++++++++++++++++
* Sub cell: CLKBUFX4
* +++++++++++++++++++++++++++++++++++++++++++++++++++++
.subckt CLKBUFX4 1 2 VSS Y A VDD
M0 4 A VSS 1 nfet_01v8 L=1.5e-07 W=7.6e-07 $X=400 $Y=590 $dt=0
M1 VSS 4 Y 1 nfet_01v8 L=1.5e-07 W=7.6e-07 $X=830 $Y=590 $dt=0
M2 Y 4 VSS 1 nfet_01v8 L=1.5e-07 W=7.6e-07 $X=1260 $Y=590 $dt=0
M3 VSS 4 Y 1 nfet_01v8 L=1.5e-07 W=7.6e-07 $X=1690 $Y=590 $dt=0
M4 Y 4 VSS 1 nfet_01v8 L=1.5e-07 W=7.6e-07 $X=2120 $Y=590 $dt=0
M5 4 A VDD 2 pfet_01v8 L=1.5e-07 W=1.13e-06 $X=400 $Y=2420 $dt=1
M6 VDD 4 Y 2 pfet_01v8 L=1.5e-07 W=1.13e-06 $X=830 $Y=2420 $dt=1
M7 Y 4 VDD 2 pfet_01v8 L=1.5e-07 W=1.13e-06 $X=1260 $Y=2420 $dt=1
M8 VDD 4 Y 2 pfet_01v8 L=1.5e-07 W=1.13e-06 $X=1690 $Y=2420 $dt=1
M9 Y 4 VDD 2 pfet_01v8 L=1.5e-07 W=1.13e-06 $X=2120 $Y=2420 $dt=1
** N=51 EP=6 NDC=10 FDC=10 HDC=10
.ends CLKBUFX4

* +++++++++++++++++++++++++++++++++++++++++++++++++++++
* Sub cell: INVX16_HS
* +++++++++++++++++++++++++++++++++++++++++++++++++++++
.subckt INVX16_HS 1 2 VSS Y A VDD
M0 VDD A Y 2 pfet_01v8 L=1.5e-07 W=1.46e-06 $X=860 $Y=2285 $dt=1
M1 Y A VDD 2 pfet_01v8 L=1.5e-07 W=1.46e-06 $X=1290 $Y=2285 $dt=1
M2 VDD A Y 2 pfet_01v8 L=1.5e-07 W=1.46e-06 $X=1720 $Y=2285 $dt=1
M3 Y A VDD 2 pfet_01v8 L=1.5e-07 W=1.46e-06 $X=2150 $Y=2285 $dt=1
M4 VDD A Y 2 pfet_01v8 L=1.5e-07 W=1.46e-06 $X=2580 $Y=2285 $dt=1
M5 Y A VDD 2 pfet_01v8 L=1.5e-07 W=1.46e-06 $X=3010 $Y=2285 $dt=1
M6 VDD A Y 2 pfet_01v8 L=1.5e-07 W=1.46e-06 $X=3440 $Y=2285 $dt=1
M7 Y A VDD 2 pfet_01v8 L=1.5e-07 W=1.46e-06 $X=3870 $Y=2285 $dt=1
M8 VDD A Y 2 pfet_01v8 L=1.5e-07 W=1.46e-06 $X=4300 $Y=2285 $dt=1
M9 Y A VDD 2 pfet_01v8 L=1.5e-07 W=1.46e-06 $X=4730 $Y=2285 $dt=1
M10 VDD A Y 2 pfet_01v8 L=1.5e-07 W=1.46e-06 $X=5160 $Y=2285 $dt=1
M11 Y A VDD 2 pfet_01v8 L=1.5e-07 W=1.46e-06 $X=5590 $Y=2285 $dt=1
M12 VDD A Y 2 pfet_01v8 L=1.5e-07 W=1.46e-06 $X=6020 $Y=2285 $dt=1
M13 Y A VDD 2 pfet_01v8 L=1.5e-07 W=1.46e-06 $X=6450 $Y=2285 $dt=1
M14 VDD A Y 2 pfet_01v8 L=1.5e-07 W=1.46e-06 $X=6880 $Y=2285 $dt=1
M15 Y A VDD 2 pfet_01v8 L=1.5e-07 W=1.46e-06 $X=7310 $Y=2285 $dt=1
M16 VSS A Y 1 nfet_01v8_lvt L=1.5e-07 W=7.6e-07 $X=860 $Y=590 $dt=3
M17 Y A VSS 1 nfet_01v8_lvt L=1.5e-07 W=7.6e-07 $X=1290 $Y=590 $dt=3
M18 VSS A Y 1 nfet_01v8_lvt L=1.5e-07 W=7.6e-07 $X=1720 $Y=590 $dt=3
M19 Y A VSS 1 nfet_01v8_lvt L=1.5e-07 W=7.6e-07 $X=2150 $Y=590 $dt=3
M20 VSS A Y 1 nfet_01v8_lvt L=1.5e-07 W=7.6e-07 $X=2580 $Y=590 $dt=3
M21 Y A VSS 1 nfet_01v8_lvt L=1.5e-07 W=7.6e-07 $X=3010 $Y=590 $dt=3
M22 VSS A Y 1 nfet_01v8_lvt L=1.5e-07 W=7.6e-07 $X=3440 $Y=590 $dt=3
M23 Y A VSS 1 nfet_01v8_lvt L=1.5e-07 W=7.6e-07 $X=3870 $Y=590 $dt=3
M24 VSS A Y 1 nfet_01v8_lvt L=1.5e-07 W=7.6e-07 $X=4300 $Y=590 $dt=3
M25 Y A VSS 1 nfet_01v8_lvt L=1.5e-07 W=7.6e-07 $X=4730 $Y=590 $dt=3
M26 VSS A Y 1 nfet_01v8_lvt L=1.5e-07 W=7.6e-07 $X=5160 $Y=590 $dt=3
M27 Y A VSS 1 nfet_01v8_lvt L=1.5e-07 W=7.6e-07 $X=5590 $Y=590 $dt=3
M28 VSS A Y 1 nfet_01v8_lvt L=1.5e-07 W=7.6e-07 $X=6020 $Y=590 $dt=3
M29 Y A VSS 1 nfet_01v8_lvt L=1.5e-07 W=7.6e-07 $X=6450 $Y=590 $dt=3
M30 VSS A Y 1 nfet_01v8_lvt L=1.5e-07 W=7.6e-07 $X=6880 $Y=590 $dt=3
M31 Y A VSS 1 nfet_01v8_lvt L=1.5e-07 W=7.6e-07 $X=7310 $Y=590 $dt=3
** N=158 EP=6 NDC=32 FDC=32 HDC=32
.ends INVX16_HS

* +++++++++++++++++++++++++++++++++++++++++++++++++++++
* Sub cell: AND2X2_HS
* +++++++++++++++++++++++++++++++++++++++++++++++++++++
.subckt AND2X2_HS 1 2 VSS Y A B VDD
M0 VDD B 4 2 pfet_01v8 L=1.5e-07 W=7.8e-07 $X=860 $Y=2965 $dt=1
M1 VDD A 4 2 pfet_01v8 L=1.5e-07 W=7.8e-07 $X=1290 $Y=2965 $dt=1
M2 VDD 4 Y 2 pfet_01v8 L=1.5e-07 W=1.46e-06 $X=1780 $Y=2285 $dt=1
M3 Y 4 VDD 2 pfet_01v8 L=1.5e-07 W=1.46e-06 $X=2210 $Y=2285 $dt=1
M4 4 B 9 1 nfet_01v8_lvt L=1.5e-07 W=4.25e-07 $X=860 $Y=395 $dt=3
M5 9 A VSS 1 nfet_01v8_lvt L=1.5e-07 W=4.25e-07 $X=1290 $Y=395 $dt=3
M6 VSS 4 Y 1 nfet_01v8_lvt L=1.5e-07 W=7.6e-07 $X=1780 $Y=395 $dt=3
M7 Y 4 VSS 1 nfet_01v8_lvt L=1.5e-07 W=7.6e-07 $X=2210 $Y=395 $dt=3
** N=49 EP=7 NDC=8 FDC=8 HDC=8
.ends AND2X2_HS

* +++++++++++++++++++++++++++++++++++++++++++++++++++++
* Sub cell: AOI21X2_HS
* +++++++++++++++++++++++++++++++++++++++++++++++++++++
.subckt AOI21X2_HS 1 2 VSS Y B0 A0 A1 VDD
M0 9 B0 Y 2 pfet_01v8 L=1.5e-07 W=1.46e-06 $X=860 $Y=2285 $dt=1
M1 Y B0 9 2 pfet_01v8 L=1.5e-07 W=1.46e-06 $X=1290 $Y=2285 $dt=1
M2 9 A0 VDD 2 pfet_01v8 L=1.5e-07 W=1.46e-06 $X=1720 $Y=2285 $dt=1
M3 VDD A0 9 2 pfet_01v8 L=1.5e-07 W=1.46e-06 $X=2150 $Y=2285 $dt=1
M4 9 A1 VDD 2 pfet_01v8 L=1.5e-07 W=1.46e-06 $X=3100 $Y=2285 $dt=1
M5 VDD A1 9 2 pfet_01v8 L=1.5e-07 W=1.46e-06 $X=3530 $Y=2285 $dt=1
M6 VSS B0 Y 1 nfet_01v8_lvt L=1.5e-07 W=7.6e-07 $X=860 $Y=590 $dt=3
M7 Y B0 VSS 1 nfet_01v8_lvt L=1.5e-07 W=7.6e-07 $X=1290 $Y=590 $dt=3
M8 VSS A0 5 1 nfet_01v8_lvt L=1.5e-07 W=7.6e-07 $X=1720 $Y=590 $dt=3
M9 5 A0 VSS 1 nfet_01v8_lvt L=1.5e-07 W=7.6e-07 $X=2150 $Y=590 $dt=3
M10 Y A1 5 1 nfet_01v8_lvt L=1.5e-07 W=7.6e-07 $X=3100 $Y=590 $dt=3
M11 5 A1 Y 1 nfet_01v8_lvt L=1.5e-07 W=7.6e-07 $X=3530 $Y=590 $dt=3
** N=82 EP=8 NDC=12 FDC=12 HDC=12
.ends AOI21X2_HS

* +++++++++++++++++++++++++++++++++++++++++++++++++++++
* Sub cell: CLKINVX4
* +++++++++++++++++++++++++++++++++++++++++++++++++++++
.subckt CLKINVX4 1 2 VSS Y A VDD
M0 VSS A Y 1 nfet_01v8 L=1.5e-07 W=7.6e-07 $X=400 $Y=590 $dt=0
M1 Y A VSS 1 nfet_01v8 L=1.5e-07 W=7.6e-07 $X=830 $Y=590 $dt=0
M2 VSS A Y 1 nfet_01v8 L=1.5e-07 W=7.6e-07 $X=1260 $Y=590 $dt=0
M3 Y A VSS 1 nfet_01v8 L=1.5e-07 W=7.6e-07 $X=1690 $Y=590 $dt=0
M4 VDD A Y 2 pfet_01v8 L=1.5e-07 W=1.13e-06 $X=400 $Y=2420 $dt=1
M5 Y A VDD 2 pfet_01v8 L=1.5e-07 W=1.13e-06 $X=830 $Y=2420 $dt=1
M6 VDD A Y 2 pfet_01v8 L=1.5e-07 W=1.13e-06 $X=1260 $Y=2420 $dt=1
M7 Y A VDD 2 pfet_01v8 L=1.5e-07 W=1.13e-06 $X=1690 $Y=2420 $dt=1
** N=40 EP=6 NDC=8 FDC=8 HDC=8
.ends CLKINVX4

* +++++++++++++++++++++++++++++++++++++++++++++++++++++
* Sub cell: NOR3X2_HS
* +++++++++++++++++++++++++++++++++++++++++++++++++++++
.subckt NOR3X2_HS 1 2 VSS Y C A B VDD
M0 VDD A 8 2 pfet_01v8 L=1.5e-07 W=1.46e-06 $X=860 $Y=2285 $dt=1
M1 8 A VDD 2 pfet_01v8 L=1.5e-07 W=1.46e-06 $X=1290 $Y=2285 $dt=1
M2 9 B 8 2 pfet_01v8 L=1.5e-07 W=1.46e-06 $X=2240 $Y=2285 $dt=1
M3 8 B 9 2 pfet_01v8 L=1.5e-07 W=1.46e-06 $X=2670 $Y=2285 $dt=1
M4 9 C Y 2 pfet_01v8 L=1.5e-07 W=1.46e-06 $X=3100 $Y=2285 $dt=1
M5 Y C 9 2 pfet_01v8 L=1.5e-07 W=1.46e-06 $X=3530 $Y=2285 $dt=1
M6 VSS A Y 1 nfet_01v8_lvt L=1.5e-07 W=7.6e-07 $X=860 $Y=395 $dt=3
M7 Y A VSS 1 nfet_01v8_lvt L=1.5e-07 W=7.6e-07 $X=1290 $Y=395 $dt=3
M8 VSS B Y 1 nfet_01v8_lvt L=1.5e-07 W=7.6e-07 $X=2240 $Y=395 $dt=3
M9 Y B VSS 1 nfet_01v8_lvt L=1.5e-07 W=7.6e-07 $X=2670 $Y=395 $dt=3
M10 VSS C Y 1 nfet_01v8_lvt L=1.5e-07 W=7.6e-07 $X=3100 $Y=395 $dt=3
M11 Y C VSS 1 nfet_01v8_lvt L=1.5e-07 W=7.6e-07 $X=3530 $Y=395 $dt=3
** N=82 EP=8 NDC=12 FDC=12 HDC=12
.ends NOR3X2_HS

* +++++++++++++++++++++++++++++++++++++++++++++++++++++
* Sub cell: OR2X2_HS
* +++++++++++++++++++++++++++++++++++++++++++++++++++++
.subckt OR2X2_HS 1 2 VSS Y B A VDD
M0 5 B 9 2 pfet_01v8 L=1.5e-07 W=7.8e-07 $X=860 $Y=2965 $dt=1
M1 VDD A 9 2 pfet_01v8 L=1.5e-07 W=7.8e-07 $X=1290 $Y=2965 $dt=1
M2 VDD 5 Y 2 pfet_01v8 L=1.5e-07 W=1.46e-06 $X=1780 $Y=2285 $dt=1
M3 Y 5 VDD 2 pfet_01v8 L=1.5e-07 W=1.46e-06 $X=2210 $Y=2285 $dt=1
M4 VSS B 5 1 nfet_01v8_lvt L=1.5e-07 W=4.25e-07 $X=860 $Y=395 $dt=3
M5 5 A VSS 1 nfet_01v8_lvt L=1.5e-07 W=4.25e-07 $X=1290 $Y=395 $dt=3
M6 VSS 5 Y 1 nfet_01v8_lvt L=1.5e-07 W=7.6e-07 $X=1780 $Y=395 $dt=3
M7 Y 5 VSS 1 nfet_01v8_lvt L=1.5e-07 W=7.6e-07 $X=2210 $Y=395 $dt=3
** N=48 EP=7 NDC=8 FDC=8 HDC=8
.ends OR2X2_HS

* +++++++++++++++++++++++++++++++++++++++++++++++++++++
* Sub cell: NAND4X2
* +++++++++++++++++++++++++++++++++++++++++++++++++++++
.subckt NAND4X2 1 2 VSS Y A C B D VDD
M0 4 A VSS 1 nfet_01v8 L=1.5e-07 W=7.6e-07 $X=400 $Y=590 $dt=0
M1 VSS A 4 1 nfet_01v8 L=1.5e-07 W=7.6e-07 $X=830 $Y=590 $dt=0
M2 4 B 6 1 nfet_01v8 L=1.5e-07 W=7.6e-07 $X=1260 $Y=590 $dt=0
M3 6 B 4 1 nfet_01v8 L=1.5e-07 W=7.6e-07 $X=1690 $Y=590 $dt=0
M4 5 C 6 1 nfet_01v8 L=1.5e-07 W=7.6e-07 $X=2640 $Y=590 $dt=0
M5 6 C 5 1 nfet_01v8 L=1.5e-07 W=7.6e-07 $X=3070 $Y=590 $dt=0
M6 5 D Y 1 nfet_01v8 L=1.5e-07 W=7.6e-07 $X=3500 $Y=590 $dt=0
M7 Y D 5 1 nfet_01v8 L=1.5e-07 W=7.6e-07 $X=3930 $Y=590 $dt=0
M8 VDD A Y 2 pfet_01v8 L=1.5e-07 W=1.13e-06 $X=400 $Y=2420 $dt=1
M9 Y A VDD 2 pfet_01v8 L=1.5e-07 W=1.13e-06 $X=830 $Y=2420 $dt=1
M10 VDD B Y 2 pfet_01v8 L=1.5e-07 W=1.13e-06 $X=1260 $Y=2420 $dt=1
M11 Y B VDD 2 pfet_01v8 L=1.5e-07 W=1.13e-06 $X=1690 $Y=2420 $dt=1
M12 VDD C Y 2 pfet_01v8 L=1.5e-07 W=1.13e-06 $X=2640 $Y=2420 $dt=1
M13 Y C VDD 2 pfet_01v8 L=1.5e-07 W=1.13e-06 $X=3070 $Y=2420 $dt=1
M14 VDD D Y 2 pfet_01v8 L=1.5e-07 W=1.13e-06 $X=3500 $Y=2420 $dt=1
M15 Y D VDD 2 pfet_01v8 L=1.5e-07 W=1.13e-06 $X=3930 $Y=2420 $dt=1
** N=87 EP=9 NDC=16 FDC=16 HDC=16
.ends NAND4X2

* +++++++++++++++++++++++++++++++++++++++++++++++++++++
* Sub cell: DFFX1
* +++++++++++++++++++++++++++++++++++++++++++++++++++++
.subckt DFFX1 1 2 VSS Q QN D CK VDD
M0 7 CK VSS 1 nfet_01v8 L=1.5e-07 W=4.25e-07 $X=400 $Y=590 $dt=0
M1 VSS D 19 1 nfet_01v8 L=1.5e-07 W=4.25e-07 $X=830 $Y=590 $dt=0
M2 19 7 8 1 nfet_01v8 L=1.5e-07 W=4.25e-07 $X=1260 $Y=590 $dt=0
M3 8 12 20 1 nfet_01v8 L=1.5e-07 W=4.25e-07 $X=1690 $Y=590 $dt=0
M4 20 9 VSS 1 nfet_01v8 L=1.5e-07 W=4.25e-07 $X=2120 $Y=590 $dt=0
M5 VSS 7 12 1 nfet_01v8 L=1.5e-07 W=4.25e-07 $X=2550 $Y=590 $dt=0
M6 VSS 8 9 1 nfet_01v8 L=1.5e-07 W=4.25e-07 $X=3500 $Y=590 $dt=0
M7 9 12 10 1 nfet_01v8 L=1.5e-07 W=4.25e-07 $X=3930 $Y=590 $dt=0
M8 10 7 21 1 nfet_01v8 L=1.5e-07 W=4.25e-07 $X=4360 $Y=590 $dt=0
M9 21 11 VSS 1 nfet_01v8 L=1.5e-07 W=4.25e-07 $X=4790 $Y=590 $dt=0
M10 VSS 10 11 1 nfet_01v8 L=1.5e-07 W=4.25e-07 $X=5220 $Y=590 $dt=0
M11 VSS 11 4 1 nfet_01v8 L=1.5e-07 W=4.25e-07 $X=6170 $Y=590 $dt=0
M12 Q 11 VSS 1 nfet_01v8 L=1.5e-07 W=7.6e-07 $X=7120 $Y=590 $dt=0
M13 VSS 4 QN 1 nfet_01v8 L=1.5e-07 W=7.6e-07 $X=7550 $Y=590 $dt=0
M14 7 CK VDD 2 pfet_01v8 L=1.5e-07 W=6.25e-07 $X=400 $Y=2925 $dt=1
M15 VDD D 16 2 pfet_01v8 L=1.5e-07 W=6.25e-07 $X=830 $Y=2925 $dt=1
M16 16 12 8 2 pfet_01v8 L=1.5e-07 W=6.25e-07 $X=1260 $Y=2925 $dt=1
M17 8 7 17 2 pfet_01v8 L=1.5e-07 W=6.25e-07 $X=1690 $Y=2925 $dt=1
M18 17 9 VDD 2 pfet_01v8 L=1.5e-07 W=6.25e-07 $X=2120 $Y=2925 $dt=1
M19 VDD 7 12 2 pfet_01v8 L=1.5e-07 W=6.25e-07 $X=2550 $Y=2925 $dt=1
M20 VDD 8 9 2 pfet_01v8 L=1.5e-07 W=6.25e-07 $X=3500 $Y=2925 $dt=1
M21 9 7 10 2 pfet_01v8 L=1.5e-07 W=6.25e-07 $X=3930 $Y=2925 $dt=1
M22 10 12 18 2 pfet_01v8 L=1.5e-07 W=6.25e-07 $X=4360 $Y=2925 $dt=1
M23 18 11 VDD 2 pfet_01v8 L=1.5e-07 W=6.25e-07 $X=4790 $Y=2925 $dt=1
M24 VDD 10 11 2 pfet_01v8 L=1.5e-07 W=6.25e-07 $X=5220 $Y=2925 $dt=1
M25 VDD 11 4 2 pfet_01v8 L=1.5e-07 W=6.25e-07 $X=6170 $Y=2925 $dt=1
M26 Q 11 VDD 2 pfet_01v8 L=1.5e-07 W=1.13e-06 $X=7120 $Y=2420 $dt=1
M27 VDD 4 QN 2 pfet_01v8 L=1.5e-07 W=1.13e-06 $X=7550 $Y=2420 $dt=1
** N=116 EP=8 NDC=28 FDC=28 HDC=28
.ends DFFX1

* +++++++++++++++++++++++++++++++++++++++++++++++++++++
* Sub cell: BUFX4
* +++++++++++++++++++++++++++++++++++++++++++++++++++++
.subckt BUFX4 1 2 VSS Y A VDD
M0 5 A VSS 1 nfet_01v8 L=1.5e-07 W=7.6e-07 $X=400 $Y=590 $dt=0
M1 VSS 5 Y 1 nfet_01v8 L=1.5e-07 W=7.6e-07 $X=830 $Y=590 $dt=0
M2 Y 5 VSS 1 nfet_01v8 L=1.5e-07 W=7.6e-07 $X=1260 $Y=590 $dt=0
M3 VSS 5 Y 1 nfet_01v8 L=1.5e-07 W=7.6e-07 $X=1690 $Y=590 $dt=0
M4 Y 5 VSS 1 nfet_01v8 L=1.5e-07 W=7.6e-07 $X=2120 $Y=590 $dt=0
M5 5 A VDD 2 pfet_01v8 L=1.5e-07 W=1.13e-06 $X=400 $Y=2420 $dt=1
M6 VDD 5 Y 2 pfet_01v8 L=1.5e-07 W=1.13e-06 $X=830 $Y=2420 $dt=1
M7 Y 5 VDD 2 pfet_01v8 L=1.5e-07 W=1.13e-06 $X=1260 $Y=2420 $dt=1
M8 VDD 5 Y 2 pfet_01v8 L=1.5e-07 W=1.13e-06 $X=1690 $Y=2420 $dt=1
M9 Y 5 VDD 2 pfet_01v8 L=1.5e-07 W=1.13e-06 $X=2120 $Y=2420 $dt=1
** N=52 EP=6 NDC=10 FDC=10 HDC=10
.ends BUFX4

* +++++++++++++++++++++++++++++++++++++++++++++++++++++
* Sub cell: CLKXOR2X1
* +++++++++++++++++++++++++++++++++++++++++++++++++++++
.subckt CLKXOR2X1 1 2 VSS Y A B VDD
M0 5 B VSS 1 nfet_01v8 L=1.5e-07 W=4.25e-07 $X=400 $Y=590 $dt=0
M1 VSS A 7 1 nfet_01v8 L=1.5e-07 W=4.25e-07 $X=830 $Y=590 $dt=0
M2 7 5 4 1 nfet_01v8 L=1.5e-07 W=4.25e-07 $X=1260 $Y=590 $dt=0
M3 4 B 12 1 nfet_01v8 L=1.5e-07 W=4.25e-07 $X=1690 $Y=590 $dt=0
M4 12 7 VSS 1 nfet_01v8 L=1.5e-07 W=4.25e-07 $X=2120 $Y=590 $dt=0
M5 VSS 4 Y 1 nfet_01v8 L=1.5e-07 W=7.6e-07 $X=2610 $Y=590 $dt=0
M6 5 B VDD 2 pfet_01v8 L=1.5e-07 W=6.25e-07 $X=400 $Y=2925 $dt=1
M7 VDD A 7 2 pfet_01v8 L=1.5e-07 W=6.25e-07 $X=830 $Y=2925 $dt=1
M8 7 B 4 2 pfet_01v8 L=1.5e-07 W=6.25e-07 $X=1260 $Y=2925 $dt=1
M9 4 5 11 2 pfet_01v8 L=1.5e-07 W=6.25e-07 $X=1690 $Y=2925 $dt=1
M10 VDD 7 11 2 pfet_01v8 L=1.5e-07 W=6.25e-07 $X=2120 $Y=2925 $dt=1
M11 VDD 4 Y 2 pfet_01v8 L=1.5e-07 W=1.13e-06 $X=2610 $Y=2420 $dt=1
** N=52 EP=7 NDC=12 FDC=12 HDC=12
.ends CLKXOR2X1

* +++++++++++++++++++++++++++++++++++++++++++++++++++++
* Sub cell: NOR2X2_HS
* +++++++++++++++++++++++++++++++++++++++++++++++++++++
.subckt NOR2X2_HS 1 2 VSS Y A B VDD
M0 7 A VDD 2 pfet_01v8 L=1.5e-07 W=1.46e-06 $X=860 $Y=2285 $dt=1
M1 VDD A 7 2 pfet_01v8 L=1.5e-07 W=1.46e-06 $X=1290 $Y=2285 $dt=1
M2 7 B Y 2 pfet_01v8 L=1.5e-07 W=1.46e-06 $X=1720 $Y=2285 $dt=1
M3 Y B 7 2 pfet_01v8 L=1.5e-07 W=1.46e-06 $X=2150 $Y=2285 $dt=1
M4 VSS A Y 1 nfet_01v8_lvt L=1.5e-07 W=7.6e-07 $X=860 $Y=395 $dt=3
M5 Y A VSS 1 nfet_01v8_lvt L=1.5e-07 W=7.6e-07 $X=1290 $Y=395 $dt=3
M6 VSS B Y 1 nfet_01v8_lvt L=1.5e-07 W=7.6e-07 $X=1720 $Y=395 $dt=3
M7 Y B VSS 1 nfet_01v8_lvt L=1.5e-07 W=7.6e-07 $X=2150 $Y=395 $dt=3
** N=54 EP=7 NDC=8 FDC=8 HDC=8
.ends NOR2X2_HS

* +++++++++++++++++++++++++++++++++++++++++++++++++++++
* Sub cell: OR2X1
* +++++++++++++++++++++++++++++++++++++++++++++++++++++
.subckt OR2X1 1 2 VSS Y B A VDD
M0 VSS B 4 1 nfet_01v8 L=1.5e-07 W=4.25e-07 $X=400 $Y=590 $dt=0
M1 4 A VSS 1 nfet_01v8 L=1.5e-07 W=4.25e-07 $X=830 $Y=590 $dt=0
M2 VSS 4 Y 1 nfet_01v8 L=1.5e-07 W=7.6e-07 $X=1320 $Y=590 $dt=0
M3 4 B 9 2 pfet_01v8 L=1.5e-07 W=6.25e-07 $X=400 $Y=2925 $dt=1
M4 VDD A 9 2 pfet_01v8 L=1.5e-07 W=6.25e-07 $X=830 $Y=2925 $dt=1
M5 VDD 4 Y 2 pfet_01v8 L=1.5e-07 W=1.13e-06 $X=1320 $Y=2420 $dt=1
** N=34 EP=7 NDC=6 FDC=6 HDC=6
.ends OR2X1

* +++++++++++++++++++++++++++++++++++++++++++++++++++++
* Sub cell: NAND2X4_HS
* +++++++++++++++++++++++++++++++++++++++++++++++++++++
.subckt NAND2X4_HS 1 2 VSS Y A B VDD
M0 VDD A Y 2 pfet_01v8 L=1.5e-07 W=1.46e-06 $X=860 $Y=2285 $dt=1
M1 Y A VDD 2 pfet_01v8 L=1.5e-07 W=1.46e-06 $X=1290 $Y=2285 $dt=1
M2 VDD A Y 2 pfet_01v8 L=1.5e-07 W=1.46e-06 $X=1720 $Y=2285 $dt=1
M3 Y A VDD 2 pfet_01v8 L=1.5e-07 W=1.46e-06 $X=2150 $Y=2285 $dt=1
M4 VDD B Y 2 pfet_01v8 L=1.5e-07 W=1.46e-06 $X=2580 $Y=2285 $dt=1
M5 Y B VDD 2 pfet_01v8 L=1.5e-07 W=1.46e-06 $X=3010 $Y=2285 $dt=1
M6 VDD B Y 2 pfet_01v8 L=1.5e-07 W=1.46e-06 $X=3440 $Y=2285 $dt=1
M7 Y B VDD 2 pfet_01v8 L=1.5e-07 W=1.46e-06 $X=3870 $Y=2285 $dt=1
M8 4 A VSS 1 nfet_01v8_lvt L=1.5e-07 W=7.6e-07 $X=860 $Y=590 $dt=3
M9 VSS A 4 1 nfet_01v8_lvt L=1.5e-07 W=7.6e-07 $X=1290 $Y=590 $dt=3
M10 4 A VSS 1 nfet_01v8_lvt L=1.5e-07 W=7.6e-07 $X=1720 $Y=590 $dt=3
M11 VSS A 4 1 nfet_01v8_lvt L=1.5e-07 W=7.6e-07 $X=2150 $Y=590 $dt=3
M12 4 B Y 1 nfet_01v8_lvt L=1.5e-07 W=7.6e-07 $X=2580 $Y=590 $dt=3
M13 Y B 4 1 nfet_01v8_lvt L=1.5e-07 W=7.6e-07 $X=3010 $Y=590 $dt=3
M14 4 B Y 1 nfet_01v8_lvt L=1.5e-07 W=7.6e-07 $X=3440 $Y=590 $dt=3
M15 Y B 4 1 nfet_01v8_lvt L=1.5e-07 W=7.6e-07 $X=3870 $Y=590 $dt=3
** N=88 EP=7 NDC=16 FDC=16 HDC=16
.ends NAND2X4_HS

* +++++++++++++++++++++++++++++++++++++++++++++++++++++
* Sub cell: OR3X1
* +++++++++++++++++++++++++++++++++++++++++++++++++++++
.subckt OR3X1 1 2 VSS Y B A C VDD
M0 4 C VSS 1 nfet_01v8 L=1.5e-07 W=4.25e-07 $X=400 $Y=590 $dt=0
M1 VSS B 4 1 nfet_01v8 L=1.5e-07 W=4.25e-07 $X=830 $Y=590 $dt=0
M2 4 A VSS 1 nfet_01v8 L=1.5e-07 W=4.25e-07 $X=1260 $Y=590 $dt=0
M3 VSS 4 Y 1 nfet_01v8 L=1.5e-07 W=7.6e-07 $X=1750 $Y=590 $dt=0
M4 4 C 10 2 pfet_01v8 L=1.5e-07 W=6.25e-07 $X=400 $Y=2925 $dt=1
M5 10 B 11 2 pfet_01v8 L=1.5e-07 W=6.25e-07 $X=830 $Y=2925 $dt=1
M6 VDD A 11 2 pfet_01v8 L=1.5e-07 W=6.25e-07 $X=1260 $Y=2925 $dt=1
M7 VDD 4 Y 2 pfet_01v8 L=1.5e-07 W=1.13e-06 $X=1750 $Y=2420 $dt=1
** N=41 EP=8 NDC=8 FDC=8 HDC=8
.ends OR3X1

* +++++++++++++++++++++++++++++++++++++++++++++++++++++
* Sub cell: CLKBUFX8_HS
* +++++++++++++++++++++++++++++++++++++++++++++++++++++
.subckt CLKBUFX8_HS 1 2 VSS Y A VDD
M0 VDD A 4 2 pfet_01v8 L=1.5e-07 W=1.06e-06 $X=860 $Y=2490 $dt=1
M1 4 A VDD 2 pfet_01v8 L=1.5e-07 W=1.06e-06 $X=1290 $Y=2490 $dt=1
M2 VDD 4 Y 2 pfet_01v8 L=1.5e-07 W=1.06e-06 $X=1720 $Y=2490 $dt=1
M3 Y 4 VDD 2 pfet_01v8 L=1.5e-07 W=1.06e-06 $X=2150 $Y=2490 $dt=1
M4 VDD 4 Y 2 pfet_01v8 L=1.5e-07 W=1.06e-06 $X=2580 $Y=2490 $dt=1
M5 Y 4 VDD 2 pfet_01v8 L=1.5e-07 W=1.06e-06 $X=3010 $Y=2490 $dt=1
M6 VDD 4 Y 2 pfet_01v8 L=1.5e-07 W=1.06e-06 $X=3440 $Y=2490 $dt=1
M7 Y 4 VDD 2 pfet_01v8 L=1.5e-07 W=1.06e-06 $X=3870 $Y=2490 $dt=1
M8 VDD 4 Y 2 pfet_01v8 L=1.5e-07 W=1.06e-06 $X=4300 $Y=2490 $dt=1
M9 Y 4 VDD 2 pfet_01v8 L=1.5e-07 W=1.06e-06 $X=4730 $Y=2490 $dt=1
M10 VDD 4 Y 2 pfet_01v8 L=1.5e-07 W=1.06e-06 $X=5160 $Y=2490 $dt=1
M11 Y 4 VDD 2 pfet_01v8 L=1.5e-07 W=1.06e-06 $X=5590 $Y=2490 $dt=1
M12 VDD 4 Y 2 pfet_01v8 L=1.5e-07 W=1.06e-06 $X=6020 $Y=2490 $dt=1
M13 Y 4 VDD 2 pfet_01v8 L=1.5e-07 W=1.06e-06 $X=6450 $Y=2490 $dt=1
M14 VDD 4 Y 2 pfet_01v8 L=1.5e-07 W=1.06e-06 $X=6880 $Y=2490 $dt=1
M15 Y 4 VDD 2 pfet_01v8 L=1.5e-07 W=1.06e-06 $X=7310 $Y=2490 $dt=1
M16 VDD 4 Y 2 pfet_01v8 L=1.5e-07 W=1.06e-06 $X=7740 $Y=2490 $dt=1
M17 Y 4 VDD 2 pfet_01v8 L=1.5e-07 W=1.06e-06 $X=8170 $Y=2490 $dt=1
M18 VSS A 4 1 nfet_01v8_lvt L=1.5e-07 W=7.6e-07 $X=860 $Y=590 $dt=3
M19 4 A VSS 1 nfet_01v8_lvt L=1.5e-07 W=7.6e-07 $X=1290 $Y=590 $dt=3
M20 VSS 4 Y 1 nfet_01v8_lvt L=1.5e-07 W=7.6e-07 $X=1720 $Y=590 $dt=3
M21 Y 4 VSS 1 nfet_01v8_lvt L=1.5e-07 W=7.6e-07 $X=2150 $Y=590 $dt=3
M22 VSS 4 Y 1 nfet_01v8_lvt L=1.5e-07 W=7.6e-07 $X=2580 $Y=590 $dt=3
M23 Y 4 VSS 1 nfet_01v8_lvt L=1.5e-07 W=7.6e-07 $X=3010 $Y=590 $dt=3
M24 VSS 4 Y 1 nfet_01v8_lvt L=1.5e-07 W=7.6e-07 $X=3440 $Y=590 $dt=3
M25 Y 4 VSS 1 nfet_01v8_lvt L=1.5e-07 W=7.6e-07 $X=3870 $Y=590 $dt=3
M26 VSS 4 Y 1 nfet_01v8_lvt L=1.5e-07 W=7.6e-07 $X=4300 $Y=590 $dt=3
M27 Y 4 VSS 1 nfet_01v8_lvt L=1.5e-07 W=7.6e-07 $X=4730 $Y=590 $dt=3
** N=139 EP=6 NDC=28 FDC=28 HDC=28
.ends CLKBUFX8_HS

* +++++++++++++++++++++++++++++++++++++++++++++++++++++
* Sub cell: CLKINVX2
* +++++++++++++++++++++++++++++++++++++++++++++++++++++
.subckt CLKINVX2 1 2 VSS Y A VDD
M0 VSS A Y 1 nfet_01v8 L=1.5e-07 W=7.6e-07 $X=400 $Y=590 $dt=0
M1 Y A VSS 1 nfet_01v8 L=1.5e-07 W=7.6e-07 $X=830 $Y=590 $dt=0
M2 VDD A Y 2 pfet_01v8 L=1.5e-07 W=1.13e-06 $X=400 $Y=2420 $dt=1
M3 Y A VDD 2 pfet_01v8 L=1.5e-07 W=1.13e-06 $X=830 $Y=2420 $dt=1
** N=27 EP=6 NDC=4 FDC=4 HDC=4
.ends CLKINVX2

* +++++++++++++++++++++++++++++++++++++++++++++++++++++
* Sub cell: MX2X1_HS
* +++++++++++++++++++++++++++++++++++++++++++++++++++++
.subckt MX2X1_HS 1 2 VSS Y A B S0 VDD
M0 5 S0 VDD 2 pfet_01v8 L=1.5e-07 W=7.8e-07 $X=860 $Y=2965 $dt=1
M1 VDD A 11 2 pfet_01v8 L=1.5e-07 W=7.8e-07 $X=1290 $Y=2965 $dt=1
M2 11 S0 6 2 pfet_01v8 L=1.5e-07 W=7.8e-07 $X=1720 $Y=2965 $dt=1
M3 6 5 12 2 pfet_01v8 L=1.5e-07 W=7.8e-07 $X=2150 $Y=2965 $dt=1
M4 VDD B 12 2 pfet_01v8 L=1.5e-07 W=7.8e-07 $X=2580 $Y=2965 $dt=1
M5 VDD 6 Y 2 pfet_01v8 L=1.5e-07 W=1.46e-06 $X=3070 $Y=2285 $dt=1
M6 5 S0 VSS 1 nfet_01v8_lvt L=1.5e-07 W=4.25e-07 $X=860 $Y=395 $dt=3
M7 VSS A 13 1 nfet_01v8_lvt L=1.5e-07 W=4.25e-07 $X=1290 $Y=395 $dt=3
M8 13 5 6 1 nfet_01v8_lvt L=1.5e-07 W=4.25e-07 $X=1720 $Y=395 $dt=3
M9 6 S0 14 1 nfet_01v8_lvt L=1.5e-07 W=4.25e-07 $X=2150 $Y=395 $dt=3
M10 14 B VSS 1 nfet_01v8_lvt L=1.5e-07 W=4.25e-07 $X=2580 $Y=395 $dt=3
M11 VSS 6 Y 1 nfet_01v8_lvt L=1.5e-07 W=7.6e-07 $X=3070 $Y=395 $dt=3
** N=62 EP=8 NDC=12 FDC=12 HDC=12
.ends MX2X1_HS

* +++++++++++++++++++++++++++++++++++++++++++++++++++++
* Sub cell: NAND4X4_HS
* +++++++++++++++++++++++++++++++++++++++++++++++++++++
.subckt NAND4X4_HS 1 2 VSS Y A B C D VDD
M0 VDD A Y 2 pfet_01v8 L=1.5e-07 W=1.46e-06 $X=860 $Y=2285 $dt=1
M1 Y A VDD 2 pfet_01v8 L=1.5e-07 W=1.46e-06 $X=1290 $Y=2285 $dt=1
M2 VDD A Y 2 pfet_01v8 L=1.5e-07 W=1.46e-06 $X=1720 $Y=2285 $dt=1
M3 Y A VDD 2 pfet_01v8 L=1.5e-07 W=1.46e-06 $X=2150 $Y=2285 $dt=1
M4 VDD B Y 2 pfet_01v8 L=1.5e-07 W=1.46e-06 $X=2580 $Y=2285 $dt=1
M5 Y B VDD 2 pfet_01v8 L=1.5e-07 W=1.46e-06 $X=3010 $Y=2285 $dt=1
M6 VDD B Y 2 pfet_01v8 L=1.5e-07 W=1.46e-06 $X=3440 $Y=2285 $dt=1
M7 Y B VDD 2 pfet_01v8 L=1.5e-07 W=1.46e-06 $X=3870 $Y=2285 $dt=1
M8 VDD C Y 2 pfet_01v8 L=1.5e-07 W=1.46e-06 $X=4820 $Y=2285 $dt=1
M9 Y C VDD 2 pfet_01v8 L=1.5e-07 W=1.46e-06 $X=5250 $Y=2285 $dt=1
M10 VDD C Y 2 pfet_01v8 L=1.5e-07 W=1.46e-06 $X=5680 $Y=2285 $dt=1
M11 Y C VDD 2 pfet_01v8 L=1.5e-07 W=1.46e-06 $X=6110 $Y=2285 $dt=1
M12 VDD D Y 2 pfet_01v8 L=1.5e-07 W=1.46e-06 $X=6540 $Y=2285 $dt=1
M13 Y D VDD 2 pfet_01v8 L=1.5e-07 W=1.46e-06 $X=6970 $Y=2285 $dt=1
M14 VDD D Y 2 pfet_01v8 L=1.5e-07 W=1.46e-06 $X=7400 $Y=2285 $dt=1
M15 Y D VDD 2 pfet_01v8 L=1.5e-07 W=1.46e-06 $X=7830 $Y=2285 $dt=1
M16 4 A VSS 1 nfet_01v8_lvt L=1.5e-07 W=7.6e-07 $X=860 $Y=395 $dt=3
M17 VSS A 4 1 nfet_01v8_lvt L=1.5e-07 W=7.6e-07 $X=1290 $Y=395 $dt=3
M18 4 A VSS 1 nfet_01v8_lvt L=1.5e-07 W=7.6e-07 $X=1720 $Y=395 $dt=3
M19 VSS A 4 1 nfet_01v8_lvt L=1.5e-07 W=7.6e-07 $X=2150 $Y=395 $dt=3
M20 4 B 6 1 nfet_01v8_lvt L=1.5e-07 W=7.6e-07 $X=2580 $Y=395 $dt=3
M21 6 B 4 1 nfet_01v8_lvt L=1.5e-07 W=7.6e-07 $X=3010 $Y=395 $dt=3
M22 4 B 6 1 nfet_01v8_lvt L=1.5e-07 W=7.6e-07 $X=3440 $Y=395 $dt=3
M23 6 B 4 1 nfet_01v8_lvt L=1.5e-07 W=7.6e-07 $X=3870 $Y=395 $dt=3
M24 5 C 6 1 nfet_01v8_lvt L=1.5e-07 W=7.6e-07 $X=4820 $Y=395 $dt=3
M25 6 C 5 1 nfet_01v8_lvt L=1.5e-07 W=7.6e-07 $X=5250 $Y=395 $dt=3
M26 5 C 6 1 nfet_01v8_lvt L=1.5e-07 W=7.6e-07 $X=5680 $Y=395 $dt=3
M27 6 C 5 1 nfet_01v8_lvt L=1.5e-07 W=7.6e-07 $X=6110 $Y=395 $dt=3
M28 5 D Y 1 nfet_01v8_lvt L=1.5e-07 W=7.6e-07 $X=6540 $Y=395 $dt=3
M29 Y D 5 1 nfet_01v8_lvt L=1.5e-07 W=7.6e-07 $X=6970 $Y=395 $dt=3
M30 5 D Y 1 nfet_01v8_lvt L=1.5e-07 W=7.6e-07 $X=7400 $Y=395 $dt=3
M31 Y D 5 1 nfet_01v8_lvt L=1.5e-07 W=7.6e-07 $X=7830 $Y=395 $dt=3
** N=168 EP=9 NDC=32 FDC=32 HDC=32
.ends NAND4X4_HS

* +++++++++++++++++++++++++++++++++++++++++++++++++++++
* Sub cell: OAI211X1
* +++++++++++++++++++++++++++++++++++++++++++++++++++++
.subckt OAI211X1 1 2 VSS Y B0 A0 A1 C0 VDD
M0 4 A0 VSS 1 nfet_01v8 L=1.5e-07 W=7.6e-07 $X=400 $Y=590 $dt=0
M1 VSS A1 4 1 nfet_01v8 L=1.5e-07 W=7.6e-07 $X=830 $Y=590 $dt=0
M2 4 B0 12 1 nfet_01v8 L=1.5e-07 W=7.6e-07 $X=1260 $Y=590 $dt=0
M3 12 C0 Y 1 nfet_01v8 L=1.5e-07 W=7.6e-07 $X=1690 $Y=590 $dt=0
M4 VDD A0 11 2 pfet_01v8 L=1.5e-07 W=1.13e-06 $X=400 $Y=2420 $dt=1
M5 11 A1 Y 2 pfet_01v8 L=1.5e-07 W=1.13e-06 $X=830 $Y=2420 $dt=1
M6 Y B0 VDD 2 pfet_01v8 L=1.5e-07 W=1.13e-06 $X=1260 $Y=2420 $dt=1
M7 VDD C0 Y 2 pfet_01v8 L=1.5e-07 W=1.13e-06 $X=1690 $Y=2420 $dt=1
** N=51 EP=9 NDC=8 FDC=8 HDC=8
.ends OAI211X1

* +++++++++++++++++++++++++++++++++++++++++++++++++++++
* Sub cell: AOI211X2_HS
* +++++++++++++++++++++++++++++++++++++++++++++++++++++
.subckt AOI211X2_HS 1 2 VSS Y B0 A0 A1 C0 VDD
M0 10 A0 VDD 2 pfet_01v8 L=1.5e-07 W=1.46e-06 $X=860 $Y=2285 $dt=1
M1 VDD A0 10 2 pfet_01v8 L=1.5e-07 W=1.46e-06 $X=1290 $Y=2285 $dt=1
M2 10 A1 VDD 2 pfet_01v8 L=1.5e-07 W=1.46e-06 $X=1720 $Y=2285 $dt=1
M3 VDD A1 10 2 pfet_01v8 L=1.5e-07 W=1.46e-06 $X=2150 $Y=2285 $dt=1
M4 11 B0 10 2 pfet_01v8 L=1.5e-07 W=1.46e-06 $X=3100 $Y=2285 $dt=1
M5 10 B0 11 2 pfet_01v8 L=1.5e-07 W=1.46e-06 $X=3530 $Y=2285 $dt=1
M6 11 C0 Y 2 pfet_01v8 L=1.5e-07 W=1.46e-06 $X=3960 $Y=2285 $dt=1
M7 Y C0 11 2 pfet_01v8 L=1.5e-07 W=1.46e-06 $X=4390 $Y=2285 $dt=1
M8 4 A0 VSS 1 nfet_01v8_lvt L=1.5e-07 W=7.6e-07 $X=860 $Y=395 $dt=3
M9 VSS A0 4 1 nfet_01v8_lvt L=1.5e-07 W=7.6e-07 $X=1290 $Y=395 $dt=3
M10 4 A1 Y 1 nfet_01v8_lvt L=1.5e-07 W=7.6e-07 $X=1720 $Y=395 $dt=3
M11 Y A1 4 1 nfet_01v8_lvt L=1.5e-07 W=7.6e-07 $X=2150 $Y=395 $dt=3
M12 VSS B0 Y 1 nfet_01v8_lvt L=1.5e-07 W=7.6e-07 $X=3100 $Y=395 $dt=3
M13 Y B0 VSS 1 nfet_01v8_lvt L=1.5e-07 W=7.6e-07 $X=3530 $Y=395 $dt=3
M14 VSS C0 Y 1 nfet_01v8_lvt L=1.5e-07 W=7.6e-07 $X=3960 $Y=395 $dt=3
M15 Y C0 VSS 1 nfet_01v8_lvt L=1.5e-07 W=7.6e-07 $X=4390 $Y=395 $dt=3
** N=102 EP=9 NDC=16 FDC=16 HDC=16
.ends AOI211X2_HS

* +++++++++++++++++++++++++++++++++++++++++++++++++++++
* Sub cell: AND2X1
* +++++++++++++++++++++++++++++++++++++++++++++++++++++
.subckt AND2X1 1 2 VSS Y B A VDD
M0 5 A 9 1 nfet_01v8 L=1.5e-07 W=4.25e-07 $X=400 $Y=590 $dt=0
M1 9 B VSS 1 nfet_01v8 L=1.5e-07 W=4.25e-07 $X=830 $Y=590 $dt=0
M2 VSS 5 Y 1 nfet_01v8 L=1.5e-07 W=7.6e-07 $X=1320 $Y=590 $dt=0
M3 VDD A 5 2 pfet_01v8 L=1.5e-07 W=6.25e-07 $X=400 $Y=2925 $dt=1
M4 VDD B 5 2 pfet_01v8 L=1.5e-07 W=6.25e-07 $X=830 $Y=2925 $dt=1
M5 VDD 5 Y 2 pfet_01v8 L=1.5e-07 W=1.13e-06 $X=1320 $Y=2420 $dt=1
** N=34 EP=7 NDC=6 FDC=6 HDC=6
.ends AND2X1

* +++++++++++++++++++++++++++++++++++++++++++++++++++++
* Sub cell: XNOR2X1_HS
* +++++++++++++++++++++++++++++++++++++++++++++++++++++
.subckt XNOR2X1_HS 1 2 VSS Y B A VDD
M0 4 B VDD 2 pfet_01v8 L=1.5e-07 W=7.8e-07 $X=860 $Y=2930 $dt=1
M1 VDD A 7 2 pfet_01v8 L=1.5e-07 W=7.8e-07 $X=1290 $Y=2930 $dt=1
M2 7 4 5 2 pfet_01v8 L=1.5e-07 W=7.8e-07 $X=1720 $Y=2930 $dt=1
M3 5 B 11 2 pfet_01v8 L=1.5e-07 W=7.8e-07 $X=2150 $Y=2930 $dt=1
M4 VDD 7 11 2 pfet_01v8 L=1.5e-07 W=7.8e-07 $X=2580 $Y=2930 $dt=1
M5 VDD 5 Y 2 pfet_01v8 L=1.5e-07 W=1.46e-06 $X=3070 $Y=2250 $dt=1
M6 4 B VSS 1 nfet_01v8_lvt L=1.5e-07 W=4.25e-07 $X=860 $Y=400 $dt=3
M7 VSS A 7 1 nfet_01v8_lvt L=1.5e-07 W=4.25e-07 $X=1290 $Y=400 $dt=3
M8 7 B 5 1 nfet_01v8_lvt L=1.5e-07 W=4.25e-07 $X=1720 $Y=400 $dt=3
M9 5 4 12 1 nfet_01v8_lvt L=1.5e-07 W=4.25e-07 $X=2150 $Y=400 $dt=3
M10 12 7 VSS 1 nfet_01v8_lvt L=1.5e-07 W=4.25e-07 $X=2580 $Y=400 $dt=3
M11 VSS 5 Y 1 nfet_01v8_lvt L=1.5e-07 W=7.6e-07 $X=3070 $Y=400 $dt=3
** N=61 EP=7 NDC=12 FDC=12 HDC=12
.ends XNOR2X1_HS

* +++++++++++++++++++++++++++++++++++++++++++++++++++++
* Sub cell: TIEHI
* +++++++++++++++++++++++++++++++++++++++++++++++++++++
.subckt TIEHI 1 2 VSS Y VDD
M0 VSS 4 4 1 nfet_01v8 L=1.5e-07 W=7.6e-07 $X=400 $Y=590 $dt=0
M1 VDD 4 Y 2 pfet_01v8 L=1.5e-07 W=1.13e-06 $X=400 $Y=2420 $dt=1
** N=21 EP=5 NDC=2 FDC=2 HDC=2
.ends TIEHI

* +++++++++++++++++++++++++++++++++++++++++++++++++++++
* Sub cell: NAND3X1_HS
* +++++++++++++++++++++++++++++++++++++++++++++++++++++
.subckt NAND3X1_HS 1 2 VSS Y A C B VDD
M0 VDD A Y 2 pfet_01v8 L=1.5e-07 W=1.46e-06 $X=860 $Y=2285 $dt=1
M1 Y B VDD 2 pfet_01v8 L=1.5e-07 W=1.46e-06 $X=1290 $Y=2285 $dt=1
M2 VDD C Y 2 pfet_01v8 L=1.5e-07 W=1.46e-06 $X=1720 $Y=2285 $dt=1
M3 VSS A 9 1 nfet_01v8_lvt L=1.5e-07 W=7.6e-07 $X=860 $Y=395 $dt=3
M4 9 B 10 1 nfet_01v8_lvt L=1.5e-07 W=7.6e-07 $X=1290 $Y=395 $dt=3
M5 10 C Y 1 nfet_01v8_lvt L=1.5e-07 W=7.6e-07 $X=1720 $Y=395 $dt=3
** N=47 EP=8 NDC=6 FDC=6 HDC=6
.ends NAND3X1_HS

* +++++++++++++++++++++++++++++++++++++++++++++++++++++
* Sub cell: NOR2X4
* +++++++++++++++++++++++++++++++++++++++++++++++++++++
.subckt NOR2X4 1 2 VSS Y A B VDD
M0 VSS A Y 1 nfet_01v8 L=1.5e-07 W=7.6e-07 $X=400 $Y=590 $dt=0
M1 Y A VSS 1 nfet_01v8 L=1.5e-07 W=7.6e-07 $X=830 $Y=590 $dt=0
M2 VSS A Y 1 nfet_01v8 L=1.5e-07 W=7.6e-07 $X=1260 $Y=590 $dt=0
M3 Y A VSS 1 nfet_01v8 L=1.5e-07 W=7.6e-07 $X=1690 $Y=590 $dt=0
M4 VSS B Y 1 nfet_01v8 L=1.5e-07 W=7.6e-07 $X=2120 $Y=590 $dt=0
M5 Y B VSS 1 nfet_01v8 L=1.5e-07 W=7.6e-07 $X=2550 $Y=590 $dt=0
M6 VSS B Y 1 nfet_01v8 L=1.5e-07 W=7.6e-07 $X=2980 $Y=590 $dt=0
M7 Y B VSS 1 nfet_01v8 L=1.5e-07 W=7.6e-07 $X=3410 $Y=590 $dt=0
M8 7 A VDD 2 pfet_01v8 L=1.5e-07 W=1.13e-06 $X=400 $Y=2420 $dt=1
M9 VDD A 7 2 pfet_01v8 L=1.5e-07 W=1.13e-06 $X=830 $Y=2420 $dt=1
M10 7 A VDD 2 pfet_01v8 L=1.5e-07 W=1.13e-06 $X=1260 $Y=2420 $dt=1
M11 VDD A 7 2 pfet_01v8 L=1.5e-07 W=1.13e-06 $X=1690 $Y=2420 $dt=1
M12 7 B Y 2 pfet_01v8 L=1.5e-07 W=1.13e-06 $X=2120 $Y=2420 $dt=1
M13 Y B 7 2 pfet_01v8 L=1.5e-07 W=1.13e-06 $X=2550 $Y=2420 $dt=1
M14 7 B Y 2 pfet_01v8 L=1.5e-07 W=1.13e-06 $X=2980 $Y=2420 $dt=1
M15 Y B 7 2 pfet_01v8 L=1.5e-07 W=1.13e-06 $X=3410 $Y=2420 $dt=1
** N=77 EP=7 NDC=16 FDC=16 HDC=16
.ends NOR2X4

* +++++++++++++++++++++++++++++++++++++++++++++++++++++
* Sub cell: BUFX4_HS
* +++++++++++++++++++++++++++++++++++++++++++++++++++++
.subckt BUFX4_HS 1 2 VSS Y A VDD
M0 5 A VDD 2 pfet_01v8 L=1.5e-07 W=1.46e-06 $X=860 $Y=2285 $dt=1
M1 VDD 5 Y 2 pfet_01v8 L=1.5e-07 W=1.46e-06 $X=1290 $Y=2285 $dt=1
M2 Y 5 VDD 2 pfet_01v8 L=1.5e-07 W=1.46e-06 $X=1720 $Y=2285 $dt=1
M3 VDD 5 Y 2 pfet_01v8 L=1.5e-07 W=1.46e-06 $X=2150 $Y=2285 $dt=1
M4 Y 5 VDD 2 pfet_01v8 L=1.5e-07 W=1.46e-06 $X=2580 $Y=2285 $dt=1
M5 5 A VSS 1 nfet_01v8_lvt L=1.5e-07 W=7.6e-07 $X=860 $Y=395 $dt=3
M6 VSS 5 Y 1 nfet_01v8_lvt L=1.5e-07 W=7.6e-07 $X=1290 $Y=395 $dt=3
M7 Y 5 VSS 1 nfet_01v8_lvt L=1.5e-07 W=7.6e-07 $X=1720 $Y=395 $dt=3
M8 VSS 5 Y 1 nfet_01v8_lvt L=1.5e-07 W=7.6e-07 $X=2150 $Y=395 $dt=3
M9 Y 5 VSS 1 nfet_01v8_lvt L=1.5e-07 W=7.6e-07 $X=2580 $Y=395 $dt=3
** N=62 EP=6 NDC=10 FDC=10 HDC=10
.ends BUFX4_HS

* +++++++++++++++++++++++++++++++++++++++++++++++++++++
* Sub cell: AOI211X1
* +++++++++++++++++++++++++++++++++++++++++++++++++++++
.subckt AOI211X1 1 2 VSS Y A0 C0 A1 B0 VDD
M0 Y A1 12 1 nfet_01v8 L=1.5e-07 W=7.6e-07 $X=400 $Y=590 $dt=0
M1 12 A0 VSS 1 nfet_01v8 L=1.5e-07 W=7.6e-07 $X=830 $Y=590 $dt=0
M2 VSS B0 Y 1 nfet_01v8 L=1.5e-07 W=7.6e-07 $X=1260 $Y=590 $dt=0
M3 Y C0 VSS 1 nfet_01v8 L=1.5e-07 W=7.6e-07 $X=1690 $Y=590 $dt=0
M4 9 A1 VDD 2 pfet_01v8 L=1.5e-07 W=1.13e-06 $X=400 $Y=2420 $dt=1
M5 VDD A0 9 2 pfet_01v8 L=1.5e-07 W=1.13e-06 $X=830 $Y=2420 $dt=1
M6 9 B0 11 2 pfet_01v8 L=1.5e-07 W=1.13e-06 $X=1260 $Y=2420 $dt=1
M7 11 C0 Y 2 pfet_01v8 L=1.5e-07 W=1.13e-06 $X=1690 $Y=2420 $dt=1
** N=51 EP=9 NDC=8 FDC=8 HDC=8
.ends AOI211X1

* +++++++++++++++++++++++++++++++++++++++++++++++++++++
* Sub cell: AOI22X2
* +++++++++++++++++++++++++++++++++++++++++++++++++++++
.subckt AOI22X2 1 2 VSS Y A1 B0 A0 B1 VDD
M0 4 A0 VSS 1 nfet_01v8 L=1.5e-07 W=7.6e-07 $X=400 $Y=590 $dt=0
M1 VSS A0 4 1 nfet_01v8 L=1.5e-07 W=7.6e-07 $X=830 $Y=590 $dt=0
M2 4 A1 Y 1 nfet_01v8 L=1.5e-07 W=7.6e-07 $X=1260 $Y=590 $dt=0
M3 Y A1 4 1 nfet_01v8 L=1.5e-07 W=7.6e-07 $X=1690 $Y=590 $dt=0
M4 5 B1 Y 1 nfet_01v8 L=1.5e-07 W=7.6e-07 $X=2640 $Y=590 $dt=0
M5 Y B1 5 1 nfet_01v8 L=1.5e-07 W=7.6e-07 $X=3070 $Y=590 $dt=0
M6 5 B0 VSS 1 nfet_01v8 L=1.5e-07 W=7.6e-07 $X=3500 $Y=590 $dt=0
M7 VSS B0 5 1 nfet_01v8 L=1.5e-07 W=7.6e-07 $X=3930 $Y=590 $dt=0
M8 11 A0 VDD 2 pfet_01v8 L=1.5e-07 W=1.13e-06 $X=400 $Y=2420 $dt=1
M9 VDD A0 11 2 pfet_01v8 L=1.5e-07 W=1.13e-06 $X=830 $Y=2420 $dt=1
M10 11 A1 VDD 2 pfet_01v8 L=1.5e-07 W=1.13e-06 $X=1260 $Y=2420 $dt=1
M11 VDD A1 11 2 pfet_01v8 L=1.5e-07 W=1.13e-06 $X=1690 $Y=2420 $dt=1
M12 11 B1 Y 2 pfet_01v8 L=1.5e-07 W=1.13e-06 $X=2640 $Y=2420 $dt=1
M13 Y B1 11 2 pfet_01v8 L=1.5e-07 W=1.13e-06 $X=3070 $Y=2420 $dt=1
M14 11 B0 Y 2 pfet_01v8 L=1.5e-07 W=1.13e-06 $X=3500 $Y=2420 $dt=1
M15 Y B0 11 2 pfet_01v8 L=1.5e-07 W=1.13e-06 $X=3930 $Y=2420 $dt=1
** N=88 EP=9 NDC=16 FDC=16 HDC=16
.ends AOI22X2

* +++++++++++++++++++++++++++++++++++++++++++++++++++++
* Sub cell: INVX1
* +++++++++++++++++++++++++++++++++++++++++++++++++++++
.subckt INVX1 1 2 VSS Y A VDD
M0 VSS A Y 1 nfet_01v8 L=1.5e-07 W=7.6e-07 $X=400 $Y=590 $dt=0
M1 VDD A Y 2 pfet_01v8 L=1.5e-07 W=1.13e-06 $X=400 $Y=2420 $dt=1
** N=21 EP=6 NDC=2 FDC=2 HDC=2
.ends INVX1

* +++++++++++++++++++++++++++++++++++++++++++++++++++++
* Sub cell: AOI21X2
* +++++++++++++++++++++++++++++++++++++++++++++++++++++
.subckt AOI21X2 1 2 VSS Y B0 A0 A1 VDD
M0 VSS B0 Y 1 nfet_01v8 L=1.5e-07 W=7.6e-07 $X=400 $Y=590 $dt=0
M1 Y B0 VSS 1 nfet_01v8 L=1.5e-07 W=7.6e-07 $X=830 $Y=590 $dt=0
M2 VSS A0 5 1 nfet_01v8 L=1.5e-07 W=7.6e-07 $X=1260 $Y=590 $dt=0
M3 5 A0 VSS 1 nfet_01v8 L=1.5e-07 W=7.6e-07 $X=1690 $Y=590 $dt=0
M4 Y A1 5 1 nfet_01v8 L=1.5e-07 W=7.6e-07 $X=2640 $Y=590 $dt=0
M5 5 A1 Y 1 nfet_01v8 L=1.5e-07 W=7.6e-07 $X=3070 $Y=590 $dt=0
M6 9 B0 Y 2 pfet_01v8 L=1.5e-07 W=1.13e-06 $X=400 $Y=2420 $dt=1
M7 Y B0 9 2 pfet_01v8 L=1.5e-07 W=1.13e-06 $X=830 $Y=2420 $dt=1
M8 9 A0 VDD 2 pfet_01v8 L=1.5e-07 W=1.13e-06 $X=1260 $Y=2420 $dt=1
M9 VDD A0 9 2 pfet_01v8 L=1.5e-07 W=1.13e-06 $X=1690 $Y=2420 $dt=1
M10 9 A1 VDD 2 pfet_01v8 L=1.5e-07 W=1.13e-06 $X=2640 $Y=2420 $dt=1
M11 VDD A1 9 2 pfet_01v8 L=1.5e-07 W=1.13e-06 $X=3070 $Y=2420 $dt=1
** N=70 EP=8 NDC=12 FDC=12 HDC=12
.ends AOI21X2

* +++++++++++++++++++++++++++++++++++++++++++++++++++++
* Sub cell: NOR2X1_HS
* +++++++++++++++++++++++++++++++++++++++++++++++++++++
.subckt NOR2X1_HS 1 2 VSS Y B A VDD
M0 VDD A 8 2 pfet_01v8 L=1.5e-07 W=1.46e-06 $X=900 $Y=2285 $dt=1
M1 8 B Y 2 pfet_01v8 L=1.5e-07 W=1.46e-06 $X=1370 $Y=2285 $dt=1
M2 VSS A Y 1 nfet_01v8_lvt L=1.5e-07 W=7.6e-07 $X=900 $Y=395 $dt=3
M3 Y B VSS 1 nfet_01v8_lvt L=1.5e-07 W=7.6e-07 $X=1370 $Y=395 $dt=3
** N=35 EP=7 NDC=4 FDC=4 HDC=4
.ends NOR2X1_HS

* +++++++++++++++++++++++++++++++++++++++++++++++++++++
* Sub cell: NOR2X2
* +++++++++++++++++++++++++++++++++++++++++++++++++++++
.subckt NOR2X2 1 2 VSS Y A B VDD
M0 VSS A Y 1 nfet_01v8 L=1.5e-07 W=7.6e-07 $X=400 $Y=590 $dt=0
M1 Y A VSS 1 nfet_01v8 L=1.5e-07 W=7.6e-07 $X=830 $Y=590 $dt=0
M2 VSS B Y 1 nfet_01v8 L=1.5e-07 W=7.6e-07 $X=1260 $Y=590 $dt=0
M3 Y B VSS 1 nfet_01v8 L=1.5e-07 W=7.6e-07 $X=1690 $Y=590 $dt=0
M4 7 A VDD 2 pfet_01v8 L=1.5e-07 W=1.13e-06 $X=400 $Y=2420 $dt=1
M5 VDD A 7 2 pfet_01v8 L=1.5e-07 W=1.13e-06 $X=830 $Y=2420 $dt=1
M6 7 B Y 2 pfet_01v8 L=1.5e-07 W=1.13e-06 $X=1260 $Y=2420 $dt=1
M7 Y B 7 2 pfet_01v8 L=1.5e-07 W=1.13e-06 $X=1690 $Y=2420 $dt=1
** N=47 EP=7 NDC=8 FDC=8 HDC=8
.ends NOR2X2

* +++++++++++++++++++++++++++++++++++++++++++++++++++++
* Sub cell: CLKINVX8_HS
* +++++++++++++++++++++++++++++++++++++++++++++++++++++
.subckt CLKINVX8_HS 1 2 VSS Y A VDD
M0 VDD A Y 2 pfet_01v8 L=1.5e-07 W=1.06e-06 $X=860 $Y=2490 $dt=1
M1 Y A VDD 2 pfet_01v8 L=1.5e-07 W=1.06e-06 $X=1290 $Y=2490 $dt=1
M2 VDD A Y 2 pfet_01v8 L=1.5e-07 W=1.06e-06 $X=1720 $Y=2490 $dt=1
M3 Y A VDD 2 pfet_01v8 L=1.5e-07 W=1.06e-06 $X=2150 $Y=2490 $dt=1
M4 VDD A Y 2 pfet_01v8 L=1.5e-07 W=1.06e-06 $X=2580 $Y=2490 $dt=1
M5 Y A VDD 2 pfet_01v8 L=1.5e-07 W=1.06e-06 $X=3010 $Y=2490 $dt=1
M6 VDD A Y 2 pfet_01v8 L=1.5e-07 W=1.06e-06 $X=3440 $Y=2490 $dt=1
M7 Y A VDD 2 pfet_01v8 L=1.5e-07 W=1.06e-06 $X=3870 $Y=2490 $dt=1
M8 VDD A Y 2 pfet_01v8 L=1.5e-07 W=1.06e-06 $X=4300 $Y=2490 $dt=1
M9 Y A VDD 2 pfet_01v8 L=1.5e-07 W=1.06e-06 $X=4730 $Y=2490 $dt=1
M10 VDD A Y 2 pfet_01v8 L=1.5e-07 W=1.06e-06 $X=5160 $Y=2490 $dt=1
M11 Y A VDD 2 pfet_01v8 L=1.5e-07 W=1.06e-06 $X=5590 $Y=2490 $dt=1
M12 VDD A Y 2 pfet_01v8 L=1.5e-07 W=1.06e-06 $X=6020 $Y=2490 $dt=1
M13 Y A VDD 2 pfet_01v8 L=1.5e-07 W=1.06e-06 $X=6450 $Y=2490 $dt=1
M14 VDD A Y 2 pfet_01v8 L=1.5e-07 W=1.06e-06 $X=6880 $Y=2490 $dt=1
M15 Y A VDD 2 pfet_01v8 L=1.5e-07 W=1.06e-06 $X=7310 $Y=2490 $dt=1
M16 VDD A Y 2 pfet_01v8 L=1.5e-07 W=1.06e-06 $X=7740 $Y=2490 $dt=1
M17 Y A VDD 2 pfet_01v8 L=1.5e-07 W=1.06e-06 $X=8170 $Y=2490 $dt=1
M18 VDD A Y 2 pfet_01v8 L=1.5e-07 W=1.06e-06 $X=8600 $Y=2490 $dt=1
M19 Y A VDD 2 pfet_01v8 L=1.5e-07 W=1.06e-06 $X=9030 $Y=2490 $dt=1
M20 VDD A Y 2 pfet_01v8 L=1.5e-07 W=1.06e-06 $X=9460 $Y=2490 $dt=1
M21 Y A VDD 2 pfet_01v8 L=1.5e-07 W=1.06e-06 $X=9890 $Y=2490 $dt=1
M22 VDD A Y 2 pfet_01v8 L=1.5e-07 W=1.06e-06 $X=10320 $Y=2490 $dt=1
M23 Y A VDD 2 pfet_01v8 L=1.5e-07 W=1.06e-06 $X=10750 $Y=2490 $dt=1
M24 VSS A Y 1 nfet_01v8_lvt L=1.5e-07 W=7.6e-07 $X=860 $Y=590 $dt=3
M25 Y A VSS 1 nfet_01v8_lvt L=1.5e-07 W=7.6e-07 $X=1290 $Y=590 $dt=3
M26 VSS A Y 1 nfet_01v8_lvt L=1.5e-07 W=7.6e-07 $X=1720 $Y=590 $dt=3
M27 Y A VSS 1 nfet_01v8_lvt L=1.5e-07 W=7.6e-07 $X=2150 $Y=590 $dt=3
M28 VSS A Y 1 nfet_01v8_lvt L=1.5e-07 W=7.6e-07 $X=2580 $Y=590 $dt=3
M29 Y A VSS 1 nfet_01v8_lvt L=1.5e-07 W=7.6e-07 $X=3010 $Y=590 $dt=3
M30 VSS A Y 1 nfet_01v8_lvt L=1.5e-07 W=7.6e-07 $X=3440 $Y=590 $dt=3
M31 Y A VSS 1 nfet_01v8_lvt L=1.5e-07 W=7.6e-07 $X=3870 $Y=590 $dt=3
** N=171 EP=6 NDC=32 FDC=32 HDC=32
.ends CLKINVX8_HS

* +++++++++++++++++++++++++++++++++++++++++++++++++++++
* Sub cell: NAND3X2_HS
* +++++++++++++++++++++++++++++++++++++++++++++++++++++
.subckt NAND3X2_HS 1 2 VSS Y C A B VDD
M0 VDD A Y 2 pfet_01v8 L=1.5e-07 W=1.46e-06 $X=860 $Y=2285 $dt=1
M1 Y A VDD 2 pfet_01v8 L=1.5e-07 W=1.46e-06 $X=1290 $Y=2285 $dt=1
M2 VDD B Y 2 pfet_01v8 L=1.5e-07 W=1.46e-06 $X=1720 $Y=2285 $dt=1
M3 Y B VDD 2 pfet_01v8 L=1.5e-07 W=1.46e-06 $X=2150 $Y=2285 $dt=1
M4 VDD C Y 2 pfet_01v8 L=1.5e-07 W=1.46e-06 $X=3100 $Y=2285 $dt=1
M5 Y C VDD 2 pfet_01v8 L=1.5e-07 W=1.46e-06 $X=3530 $Y=2285 $dt=1
M6 5 A VSS 1 nfet_01v8_lvt L=1.5e-07 W=7.6e-07 $X=860 $Y=395 $dt=3
M7 VSS A 5 1 nfet_01v8_lvt L=1.5e-07 W=7.6e-07 $X=1290 $Y=395 $dt=3
M8 5 B 4 1 nfet_01v8_lvt L=1.5e-07 W=7.6e-07 $X=1720 $Y=395 $dt=3
M9 4 B 5 1 nfet_01v8_lvt L=1.5e-07 W=7.6e-07 $X=2150 $Y=395 $dt=3
M10 4 C Y 1 nfet_01v8_lvt L=1.5e-07 W=7.6e-07 $X=3100 $Y=395 $dt=3
M11 Y C 4 1 nfet_01v8_lvt L=1.5e-07 W=7.6e-07 $X=3530 $Y=395 $dt=3
** N=82 EP=8 NDC=12 FDC=12 HDC=12
.ends NAND3X2_HS

* +++++++++++++++++++++++++++++++++++++++++++++++++++++
* Sub cell: OAI21X1_HS
* +++++++++++++++++++++++++++++++++++++++++++++++++++++
.subckt OAI21X1_HS 1 2 VSS Y A0 B0 A1 VDD
M0 VDD A0 10 2 pfet_01v8 L=1.5e-07 W=1.46e-06 $X=860 $Y=2285 $dt=1
M1 10 A1 Y 2 pfet_01v8 L=1.5e-07 W=1.46e-06 $X=1290 $Y=2285 $dt=1
M2 Y B0 VDD 2 pfet_01v8 L=1.5e-07 W=1.46e-06 $X=1720 $Y=2285 $dt=1
M3 4 A0 VSS 1 nfet_01v8_lvt L=1.5e-07 W=7.6e-07 $X=860 $Y=395 $dt=3
M4 VSS A1 4 1 nfet_01v8_lvt L=1.5e-07 W=7.6e-07 $X=1290 $Y=395 $dt=3
M5 4 B0 Y 1 nfet_01v8_lvt L=1.5e-07 W=7.6e-07 $X=1720 $Y=395 $dt=3
** N=46 EP=8 NDC=6 FDC=6 HDC=6
.ends OAI21X1_HS

* +++++++++++++++++++++++++++++++++++++++++++++++++++++
* Sub cell: AOI22X1_HS
* +++++++++++++++++++++++++++++++++++++++++++++++++++++
.subckt AOI22X1_HS 1 2 VSS Y B1 A0 B0 A1 VDD
M0 9 A0 VDD 2 pfet_01v8 L=1.5e-07 W=1.46e-06 $X=860 $Y=2285 $dt=1
M1 VDD A1 9 2 pfet_01v8 L=1.5e-07 W=1.46e-06 $X=1290 $Y=2285 $dt=1
M2 9 B1 Y 2 pfet_01v8 L=1.5e-07 W=1.46e-06 $X=1720 $Y=2285 $dt=1
M3 Y B0 9 2 pfet_01v8 L=1.5e-07 W=1.46e-06 $X=2150 $Y=2285 $dt=1
M4 VSS A0 11 1 nfet_01v8_lvt L=1.5e-07 W=7.6e-07 $X=860 $Y=395 $dt=3
M5 11 A1 Y 1 nfet_01v8_lvt L=1.5e-07 W=7.6e-07 $X=1290 $Y=395 $dt=3
M6 Y B1 12 1 nfet_01v8_lvt L=1.5e-07 W=7.6e-07 $X=1720 $Y=395 $dt=3
M7 12 B0 VSS 1 nfet_01v8_lvt L=1.5e-07 W=7.6e-07 $X=2150 $Y=395 $dt=3
** N=58 EP=9 NDC=8 FDC=8 HDC=8
.ends AOI22X1_HS

* +++++++++++++++++++++++++++++++++++++++++++++++++++++
* Sub cell: BUFX16_HS
* +++++++++++++++++++++++++++++++++++++++++++++++++++++
.subckt BUFX16_HS 1 2 VSS Y A VDD
M0 VDD A 4 2 pfet_01v8 L=1.5e-07 W=1.46e-06 $X=860 $Y=2285 $dt=1
M1 4 A VDD 2 pfet_01v8 L=1.5e-07 W=1.46e-06 $X=1290 $Y=2285 $dt=1
M2 VDD A 4 2 pfet_01v8 L=1.5e-07 W=1.46e-06 $X=1720 $Y=2285 $dt=1
M3 4 A VDD 2 pfet_01v8 L=1.5e-07 W=1.46e-06 $X=2150 $Y=2285 $dt=1
M4 VDD 4 Y 2 pfet_01v8 L=1.5e-07 W=1.46e-06 $X=2580 $Y=2285 $dt=1
M5 Y 4 VDD 2 pfet_01v8 L=1.5e-07 W=1.46e-06 $X=3010 $Y=2285 $dt=1
M6 VDD 4 Y 2 pfet_01v8 L=1.5e-07 W=1.46e-06 $X=3440 $Y=2285 $dt=1
M7 Y 4 VDD 2 pfet_01v8 L=1.5e-07 W=1.46e-06 $X=3870 $Y=2285 $dt=1
M8 VDD 4 Y 2 pfet_01v8 L=1.5e-07 W=1.46e-06 $X=4300 $Y=2285 $dt=1
M9 Y 4 VDD 2 pfet_01v8 L=1.5e-07 W=1.46e-06 $X=4730 $Y=2285 $dt=1
M10 VDD 4 Y 2 pfet_01v8 L=1.5e-07 W=1.46e-06 $X=5160 $Y=2285 $dt=1
M11 Y 4 VDD 2 pfet_01v8 L=1.5e-07 W=1.46e-06 $X=5590 $Y=2285 $dt=1
M12 VDD 4 Y 2 pfet_01v8 L=1.5e-07 W=1.46e-06 $X=6020 $Y=2285 $dt=1
M13 Y 4 VDD 2 pfet_01v8 L=1.5e-07 W=1.46e-06 $X=6450 $Y=2285 $dt=1
M14 VDD 4 Y 2 pfet_01v8 L=1.5e-07 W=1.46e-06 $X=6880 $Y=2285 $dt=1
M15 Y 4 VDD 2 pfet_01v8 L=1.5e-07 W=1.46e-06 $X=7310 $Y=2285 $dt=1
M16 VDD 4 Y 2 pfet_01v8 L=1.5e-07 W=1.46e-06 $X=7740 $Y=2285 $dt=1
M17 Y 4 VDD 2 pfet_01v8 L=1.5e-07 W=1.46e-06 $X=8170 $Y=2285 $dt=1
M18 VDD 4 Y 2 pfet_01v8 L=1.5e-07 W=1.46e-06 $X=8600 $Y=2285 $dt=1
M19 Y 4 VDD 2 pfet_01v8 L=1.5e-07 W=1.46e-06 $X=9030 $Y=2285 $dt=1
M20 VSS A 4 1 nfet_01v8_lvt L=1.5e-07 W=7.6e-07 $X=860 $Y=395 $dt=3
M21 4 A VSS 1 nfet_01v8_lvt L=1.5e-07 W=7.6e-07 $X=1290 $Y=395 $dt=3
M22 VSS A 4 1 nfet_01v8_lvt L=1.5e-07 W=7.6e-07 $X=1720 $Y=395 $dt=3
M23 4 A VSS 1 nfet_01v8_lvt L=1.5e-07 W=7.6e-07 $X=2150 $Y=395 $dt=3
M24 VSS 4 Y 1 nfet_01v8_lvt L=1.5e-07 W=7.6e-07 $X=2580 $Y=395 $dt=3
M25 Y 4 VSS 1 nfet_01v8_lvt L=1.5e-07 W=7.6e-07 $X=3010 $Y=395 $dt=3
M26 VSS 4 Y 1 nfet_01v8_lvt L=1.5e-07 W=7.6e-07 $X=3440 $Y=395 $dt=3
M27 Y 4 VSS 1 nfet_01v8_lvt L=1.5e-07 W=7.6e-07 $X=3870 $Y=395 $dt=3
M28 VSS 4 Y 1 nfet_01v8_lvt L=1.5e-07 W=7.6e-07 $X=4300 $Y=395 $dt=3
M29 Y 4 VSS 1 nfet_01v8_lvt L=1.5e-07 W=7.6e-07 $X=4730 $Y=395 $dt=3
M30 VSS 4 Y 1 nfet_01v8_lvt L=1.5e-07 W=7.6e-07 $X=5160 $Y=395 $dt=3
M31 Y 4 VSS 1 nfet_01v8_lvt L=1.5e-07 W=7.6e-07 $X=5590 $Y=395 $dt=3
M32 VSS 4 Y 1 nfet_01v8_lvt L=1.5e-07 W=7.6e-07 $X=6020 $Y=395 $dt=3
M33 Y 4 VSS 1 nfet_01v8_lvt L=1.5e-07 W=7.6e-07 $X=6450 $Y=395 $dt=3
M34 VSS 4 Y 1 nfet_01v8_lvt L=1.5e-07 W=7.6e-07 $X=6880 $Y=395 $dt=3
M35 Y 4 VSS 1 nfet_01v8_lvt L=1.5e-07 W=7.6e-07 $X=7310 $Y=395 $dt=3
M36 VSS 4 Y 1 nfet_01v8_lvt L=1.5e-07 W=7.6e-07 $X=7740 $Y=395 $dt=3
M37 Y 4 VSS 1 nfet_01v8_lvt L=1.5e-07 W=7.6e-07 $X=8170 $Y=395 $dt=3
M38 VSS 4 Y 1 nfet_01v8_lvt L=1.5e-07 W=7.6e-07 $X=8600 $Y=395 $dt=3
M39 Y 4 VSS 1 nfet_01v8_lvt L=1.5e-07 W=7.6e-07 $X=9030 $Y=395 $dt=3
** N=193 EP=6 NDC=40 FDC=40 HDC=40
.ends BUFX16_HS

* +++++++++++++++++++++++++++++++++++++++++++++++++++++
* Sub cell: XOR2X1_HS
* +++++++++++++++++++++++++++++++++++++++++++++++++++++
.subckt XOR2X1_HS 1 2 VSS Y A B VDD
M0 6 B VDD 2 pfet_01v8 L=1.5e-07 W=7.8e-07 $X=860 $Y=2965 $dt=1
M1 VDD A 7 2 pfet_01v8 L=1.5e-07 W=7.8e-07 $X=1290 $Y=2965 $dt=1
M2 7 B 4 2 pfet_01v8 L=1.5e-07 W=7.8e-07 $X=1720 $Y=2965 $dt=1
M3 4 6 11 2 pfet_01v8 L=1.5e-07 W=7.8e-07 $X=2150 $Y=2965 $dt=1
M4 VDD 7 11 2 pfet_01v8 L=1.5e-07 W=7.8e-07 $X=2580 $Y=2965 $dt=1
M5 VDD 4 Y 2 pfet_01v8 L=1.5e-07 W=1.46e-06 $X=3070 $Y=2285 $dt=1
M6 6 B VSS 1 nfet_01v8_lvt L=1.5e-07 W=4.25e-07 $X=860 $Y=395 $dt=3
M7 VSS A 7 1 nfet_01v8_lvt L=1.5e-07 W=4.25e-07 $X=1290 $Y=395 $dt=3
M8 7 6 4 1 nfet_01v8_lvt L=1.5e-07 W=4.25e-07 $X=1720 $Y=395 $dt=3
M9 4 B 12 1 nfet_01v8_lvt L=1.5e-07 W=4.25e-07 $X=2150 $Y=395 $dt=3
M10 12 7 VSS 1 nfet_01v8_lvt L=1.5e-07 W=4.25e-07 $X=2580 $Y=395 $dt=3
M11 VSS 4 Y 1 nfet_01v8_lvt L=1.5e-07 W=7.6e-07 $X=3070 $Y=395 $dt=3
** N=62 EP=7 NDC=12 FDC=12 HDC=12
.ends XOR2X1_HS

* +++++++++++++++++++++++++++++++++++++++++++++++++++++
* Sub cell: DFFRX1_HS
* +++++++++++++++++++++++++++++++++++++++++++++++++++++
.subckt DFFRX1_HS 1 2 VSS Q QN D RN CK VDD
M0 7 CK VDD 2 pfet_01v8 L=1.5e-07 W=7.8e-07 $X=860 $Y=2965 $dt=1
M1 VDD D 18 2 pfet_01v8 L=1.5e-07 W=7.8e-07 $X=1290 $Y=2965 $dt=1
M2 18 9 8 2 pfet_01v8 L=1.5e-07 W=7.8e-07 $X=1720 $Y=2965 $dt=1
M3 8 7 16 2 pfet_01v8 L=1.5e-07 W=7.8e-07 $X=2150 $Y=2965 $dt=1
M4 16 10 VDD 2 pfet_01v8 L=1.5e-07 W=7.8e-07 $X=2580 $Y=2965 $dt=1
M5 VDD RN 16 2 pfet_01v8 L=1.5e-07 W=7.8e-07 $X=3010 $Y=2965 $dt=1
M6 9 7 VDD 2 pfet_01v8 L=1.5e-07 W=7.8e-07 $X=3960 $Y=2965 $dt=1
M7 VDD 8 10 2 pfet_01v8 L=1.5e-07 W=7.8e-07 $X=4390 $Y=2965 $dt=1
M8 10 7 11 2 pfet_01v8 L=1.5e-07 W=7.8e-07 $X=4820 $Y=2965 $dt=1
M9 11 9 19 2 pfet_01v8 L=1.5e-07 W=7.8e-07 $X=5250 $Y=2965 $dt=1
M10 19 12 VDD 2 pfet_01v8 L=1.5e-07 W=7.8e-07 $X=5680 $Y=2965 $dt=1
M11 VDD 11 12 2 pfet_01v8 L=1.5e-07 W=7.8e-07 $X=6630 $Y=2965 $dt=1
M12 12 RN VDD 2 pfet_01v8 L=1.5e-07 W=7.8e-07 $X=7060 $Y=2965 $dt=1
M13 VDD 12 4 2 pfet_01v8 L=1.5e-07 W=7.8e-07 $X=7490 $Y=2965 $dt=1
M14 Q 12 VDD 2 pfet_01v8 L=1.5e-07 W=1.46e-06 $X=8440 $Y=2285 $dt=1
M15 VDD 4 QN 2 pfet_01v8 L=1.5e-07 W=1.46e-06 $X=8870 $Y=2285 $dt=1
M16 7 CK VSS 1 nfet_01v8_lvt L=1.5e-07 W=4.25e-07 $X=860 $Y=395 $dt=3
M17 VSS D 20 1 nfet_01v8_lvt L=1.5e-07 W=4.25e-07 $X=1290 $Y=395 $dt=3
M18 20 7 8 1 nfet_01v8_lvt L=1.5e-07 W=4.25e-07 $X=1720 $Y=395 $dt=3
M19 8 9 21 1 nfet_01v8_lvt L=1.5e-07 W=4.25e-07 $X=2150 $Y=395 $dt=3
M20 21 10 22 1 nfet_01v8_lvt L=1.5e-07 W=4.25e-07 $X=2580 $Y=395 $dt=3
M21 22 RN VSS 1 nfet_01v8_lvt L=1.5e-07 W=4.25e-07 $X=3010 $Y=395 $dt=3
M22 9 7 VSS 1 nfet_01v8_lvt L=1.5e-07 W=4.25e-07 $X=3960 $Y=395 $dt=3
M23 VSS 8 10 1 nfet_01v8_lvt L=1.5e-07 W=4.25e-07 $X=4390 $Y=395 $dt=3
M24 10 9 11 1 nfet_01v8_lvt L=1.5e-07 W=4.25e-07 $X=4820 $Y=395 $dt=3
M25 11 7 23 1 nfet_01v8_lvt L=1.5e-07 W=4.25e-07 $X=5250 $Y=395 $dt=3
M26 23 12 VSS 1 nfet_01v8_lvt L=1.5e-07 W=4.25e-07 $X=5680 $Y=395 $dt=3
M27 12 11 24 1 nfet_01v8_lvt L=1.5e-07 W=4.25e-07 $X=6630 $Y=395 $dt=3
M28 24 RN VSS 1 nfet_01v8_lvt L=1.5e-07 W=4.25e-07 $X=7060 $Y=395 $dt=3
M29 VSS 12 4 1 nfet_01v8_lvt L=1.5e-07 W=4.25e-07 $X=7490 $Y=395 $dt=3
M30 Q 12 VSS 1 nfet_01v8_lvt L=1.5e-07 W=7.6e-07 $X=8440 $Y=395 $dt=3
M31 VSS 4 QN 1 nfet_01v8_lvt L=1.5e-07 W=7.6e-07 $X=8870 $Y=395 $dt=3
** N=149 EP=9 NDC=32 FDC=32 HDC=32
.ends DFFRX1_HS

* +++++++++++++++++++++++++++++++++++++++++++++++++++++
* Sub cell: AOI22X2_HS
* +++++++++++++++++++++++++++++++++++++++++++++++++++++
.subckt AOI22X2_HS 1 2 VSS Y A1 B0 A0 B1 VDD
M0 11 A0 VDD 2 pfet_01v8 L=1.5e-07 W=1.46e-06 $X=860 $Y=2285 $dt=1
M1 VDD A0 11 2 pfet_01v8 L=1.5e-07 W=1.46e-06 $X=1290 $Y=2285 $dt=1
M2 11 A1 VDD 2 pfet_01v8 L=1.5e-07 W=1.46e-06 $X=1720 $Y=2285 $dt=1
M3 VDD A1 11 2 pfet_01v8 L=1.5e-07 W=1.46e-06 $X=2150 $Y=2285 $dt=1
M4 11 B1 Y 2 pfet_01v8 L=1.5e-07 W=1.46e-06 $X=3100 $Y=2285 $dt=1
M5 Y B1 11 2 pfet_01v8 L=1.5e-07 W=1.46e-06 $X=3530 $Y=2285 $dt=1
M6 11 B0 Y 2 pfet_01v8 L=1.5e-07 W=1.46e-06 $X=3960 $Y=2285 $dt=1
M7 Y B0 11 2 pfet_01v8 L=1.5e-07 W=1.46e-06 $X=4390 $Y=2285 $dt=1
M8 4 A0 VSS 1 nfet_01v8_lvt L=1.5e-07 W=7.6e-07 $X=860 $Y=395 $dt=3
M9 VSS A0 4 1 nfet_01v8_lvt L=1.5e-07 W=7.6e-07 $X=1290 $Y=395 $dt=3
M10 4 A1 Y 1 nfet_01v8_lvt L=1.5e-07 W=7.6e-07 $X=1720 $Y=395 $dt=3
M11 Y A1 4 1 nfet_01v8_lvt L=1.5e-07 W=7.6e-07 $X=2150 $Y=395 $dt=3
M12 5 B1 Y 1 nfet_01v8_lvt L=1.5e-07 W=7.6e-07 $X=3100 $Y=395 $dt=3
M13 Y B1 5 1 nfet_01v8_lvt L=1.5e-07 W=7.6e-07 $X=3530 $Y=395 $dt=3
M14 5 B0 VSS 1 nfet_01v8_lvt L=1.5e-07 W=7.6e-07 $X=3960 $Y=395 $dt=3
M15 VSS B0 5 1 nfet_01v8_lvt L=1.5e-07 W=7.6e-07 $X=4390 $Y=395 $dt=3
** N=102 EP=9 NDC=16 FDC=16 HDC=16
.ends AOI22X2_HS

* +++++++++++++++++++++++++++++++++++++++++++++++++++++
* Sub cell: NAND3X1
* +++++++++++++++++++++++++++++++++++++++++++++++++++++
.subckt NAND3X1 1 2 VSS Y A C B VDD
M0 VSS A 9 1 nfet_01v8 L=1.5e-07 W=7.6e-07 $X=400 $Y=590 $dt=0
M1 9 B 10 1 nfet_01v8 L=1.5e-07 W=7.6e-07 $X=830 $Y=590 $dt=0
M2 10 C Y 1 nfet_01v8 L=1.5e-07 W=7.6e-07 $X=1260 $Y=590 $dt=0
M3 VDD A Y 2 pfet_01v8 L=1.5e-07 W=1.13e-06 $X=400 $Y=2420 $dt=1
M4 Y B VDD 2 pfet_01v8 L=1.5e-07 W=1.13e-06 $X=830 $Y=2420 $dt=1
M5 VDD C Y 2 pfet_01v8 L=1.5e-07 W=1.13e-06 $X=1260 $Y=2420 $dt=1
** N=41 EP=8 NDC=6 FDC=6 HDC=6
.ends NAND3X1

* +++++++++++++++++++++++++++++++++++++++++++++++++++++
* Sub cell: CLKBUFX2
* +++++++++++++++++++++++++++++++++++++++++++++++++++++
.subckt CLKBUFX2 1 2 VSS Y A VDD
M0 5 A VSS 1 nfet_01v8 L=1.5e-07 W=4.25e-07 $X=400 $Y=590 $dt=0
M1 VSS 5 Y 1 nfet_01v8 L=1.5e-07 W=7.6e-07 $X=890 $Y=590 $dt=0
M2 Y 5 VSS 1 nfet_01v8 L=1.5e-07 W=7.6e-07 $X=1320 $Y=590 $dt=0
M3 VDD A 5 2 pfet_01v8 L=1.5e-07 W=6.25e-07 $X=400 $Y=2925 $dt=1
M4 VDD 5 Y 2 pfet_01v8 L=1.5e-07 W=1.13e-06 $X=890 $Y=2420 $dt=1
M5 Y 5 VDD 2 pfet_01v8 L=1.5e-07 W=1.13e-06 $X=1320 $Y=2420 $dt=1
** N=35 EP=6 NDC=6 FDC=6 HDC=6
.ends CLKBUFX2

* +++++++++++++++++++++++++++++++++++++++++++++++++++++
* Sub cell: INVX8_HS
* +++++++++++++++++++++++++++++++++++++++++++++++++++++
.subckt INVX8_HS 1 2 VSS Y A VDD
M0 VDD A Y 2 pfet_01v8 L=1.5e-07 W=1.46e-06 $X=860 $Y=2285 $dt=1
M1 Y A VDD 2 pfet_01v8 L=1.5e-07 W=1.46e-06 $X=1290 $Y=2285 $dt=1
M2 VDD A Y 2 pfet_01v8 L=1.5e-07 W=1.46e-06 $X=1720 $Y=2285 $dt=1
M3 Y A VDD 2 pfet_01v8 L=1.5e-07 W=1.46e-06 $X=2150 $Y=2285 $dt=1
M4 VDD A Y 2 pfet_01v8 L=1.5e-07 W=1.46e-06 $X=2580 $Y=2285 $dt=1
M5 Y A VDD 2 pfet_01v8 L=1.5e-07 W=1.46e-06 $X=3010 $Y=2285 $dt=1
M6 VDD A Y 2 pfet_01v8 L=1.5e-07 W=1.46e-06 $X=3440 $Y=2285 $dt=1
M7 Y A VDD 2 pfet_01v8 L=1.5e-07 W=1.46e-06 $X=3870 $Y=2285 $dt=1
M8 VSS A Y 1 nfet_01v8_lvt L=1.5e-07 W=7.6e-07 $X=860 $Y=590 $dt=3
M9 Y A VSS 1 nfet_01v8_lvt L=1.5e-07 W=7.6e-07 $X=1290 $Y=590 $dt=3
M10 VSS A Y 1 nfet_01v8_lvt L=1.5e-07 W=7.6e-07 $X=1720 $Y=590 $dt=3
M11 Y A VSS 1 nfet_01v8_lvt L=1.5e-07 W=7.6e-07 $X=2150 $Y=590 $dt=3
M12 VSS A Y 1 nfet_01v8_lvt L=1.5e-07 W=7.6e-07 $X=2580 $Y=590 $dt=3
M13 Y A VSS 1 nfet_01v8_lvt L=1.5e-07 W=7.6e-07 $X=3010 $Y=590 $dt=3
M14 VSS A Y 1 nfet_01v8_lvt L=1.5e-07 W=7.6e-07 $X=3440 $Y=590 $dt=3
M15 Y A VSS 1 nfet_01v8_lvt L=1.5e-07 W=7.6e-07 $X=3870 $Y=590 $dt=3
** N=88 EP=6 NDC=16 FDC=16 HDC=16
.ends INVX8_HS

* +++++++++++++++++++++++++++++++++++++++++++++++++++++
* Sub cell: DFFX1_HS
* +++++++++++++++++++++++++++++++++++++++++++++++++++++
.subckt DFFX1_HS 1 2 VSS Q QN D CK VDD
M0 5 CK VDD 2 pfet_01v8 L=1.5e-07 W=7.8e-07 $X=860 $Y=2965 $dt=1
M1 VDD D 16 2 pfet_01v8 L=1.5e-07 W=7.8e-07 $X=1290 $Y=2965 $dt=1
M2 16 12 6 2 pfet_01v8 L=1.5e-07 W=7.8e-07 $X=1720 $Y=2965 $dt=1
M3 6 5 17 2 pfet_01v8 L=1.5e-07 W=7.8e-07 $X=2150 $Y=2965 $dt=1
M4 17 7 VDD 2 pfet_01v8 L=1.5e-07 W=7.8e-07 $X=2580 $Y=2965 $dt=1
M5 VDD 5 12 2 pfet_01v8 L=1.5e-07 W=7.8e-07 $X=3010 $Y=2965 $dt=1
M6 VDD 6 7 2 pfet_01v8 L=1.5e-07 W=7.8e-07 $X=3960 $Y=2965 $dt=1
M7 7 5 8 2 pfet_01v8 L=1.5e-07 W=7.8e-07 $X=4390 $Y=2965 $dt=1
M8 8 12 18 2 pfet_01v8 L=1.5e-07 W=7.8e-07 $X=4820 $Y=2965 $dt=1
M9 18 11 VDD 2 pfet_01v8 L=1.5e-07 W=7.8e-07 $X=5250 $Y=2965 $dt=1
M10 VDD 8 11 2 pfet_01v8 L=1.5e-07 W=7.8e-07 $X=5680 $Y=2965 $dt=1
M11 VDD 11 4 2 pfet_01v8 L=1.5e-07 W=7.8e-07 $X=6630 $Y=2965 $dt=1
M12 Q 11 VDD 2 pfet_01v8 L=1.5e-07 W=1.46e-06 $X=7580 $Y=2285 $dt=1
M13 VDD 4 QN 2 pfet_01v8 L=1.5e-07 W=1.46e-06 $X=8010 $Y=2285 $dt=1
M14 5 CK VSS 1 nfet_01v8_lvt L=1.5e-07 W=4.25e-07 $X=860 $Y=395 $dt=3
M15 VSS D 19 1 nfet_01v8_lvt L=1.5e-07 W=4.25e-07 $X=1290 $Y=395 $dt=3
M16 19 5 6 1 nfet_01v8_lvt L=1.5e-07 W=4.25e-07 $X=1720 $Y=395 $dt=3
M17 6 12 20 1 nfet_01v8_lvt L=1.5e-07 W=4.25e-07 $X=2150 $Y=395 $dt=3
M18 20 7 VSS 1 nfet_01v8_lvt L=1.5e-07 W=4.25e-07 $X=2580 $Y=395 $dt=3
M19 VSS 5 12 1 nfet_01v8_lvt L=1.5e-07 W=4.25e-07 $X=3010 $Y=395 $dt=3
M20 VSS 6 7 1 nfet_01v8_lvt L=1.5e-07 W=4.25e-07 $X=3960 $Y=395 $dt=3
M21 7 12 8 1 nfet_01v8_lvt L=1.5e-07 W=4.25e-07 $X=4390 $Y=395 $dt=3
M22 8 5 21 1 nfet_01v8_lvt L=1.5e-07 W=4.25e-07 $X=4820 $Y=395 $dt=3
M23 21 11 VSS 1 nfet_01v8_lvt L=1.5e-07 W=4.25e-07 $X=5250 $Y=395 $dt=3
M24 VSS 8 11 1 nfet_01v8_lvt L=1.5e-07 W=4.25e-07 $X=5680 $Y=395 $dt=3
M25 VSS 11 4 1 nfet_01v8_lvt L=1.5e-07 W=4.25e-07 $X=6630 $Y=395 $dt=3
M26 Q 11 VSS 1 nfet_01v8_lvt L=1.5e-07 W=7.6e-07 $X=7580 $Y=395 $dt=3
M27 VSS 4 QN 1 nfet_01v8_lvt L=1.5e-07 W=7.6e-07 $X=8010 $Y=395 $dt=3
** N=135 EP=8 NDC=28 FDC=28 HDC=28
.ends DFFX1_HS

* +++++++++++++++++++++++++++++++++++++++++++++++++++++
* Sub cell: NAND4X1_HS
* +++++++++++++++++++++++++++++++++++++++++++++++++++++
.subckt NAND4X1_HS 1 2 VSS Y B D A C VDD
M0 VDD A Y 2 pfet_01v8 L=1.5e-07 W=1.46e-06 $X=860 $Y=2285 $dt=1
M1 Y B VDD 2 pfet_01v8 L=1.5e-07 W=1.46e-06 $X=1290 $Y=2285 $dt=1
M2 VDD C Y 2 pfet_01v8 L=1.5e-07 W=1.46e-06 $X=1720 $Y=2285 $dt=1
M3 Y D VDD 2 pfet_01v8 L=1.5e-07 W=1.46e-06 $X=2150 $Y=2285 $dt=1
M4 VSS A 10 1 nfet_01v8_lvt L=1.5e-07 W=7.6e-07 $X=860 $Y=395 $dt=3
M5 10 B 11 1 nfet_01v8_lvt L=1.5e-07 W=7.6e-07 $X=1290 $Y=395 $dt=3
M6 11 C 12 1 nfet_01v8_lvt L=1.5e-07 W=7.6e-07 $X=1720 $Y=395 $dt=3
M7 12 D Y 1 nfet_01v8_lvt L=1.5e-07 W=7.6e-07 $X=2150 $Y=395 $dt=3
** N=58 EP=9 NDC=8 FDC=8 HDC=8
.ends NAND4X1_HS

* +++++++++++++++++++++++++++++++++++++++++++++++++++++
* Sub cell: NAND2X4
* +++++++++++++++++++++++++++++++++++++++++++++++++++++
.subckt NAND2X4 1 2 VSS Y A B VDD
M0 4 A VSS 1 nfet_01v8 L=1.5e-07 W=7.6e-07 $X=400 $Y=590 $dt=0
M1 VSS A 4 1 nfet_01v8 L=1.5e-07 W=7.6e-07 $X=830 $Y=590 $dt=0
M2 4 A VSS 1 nfet_01v8 L=1.5e-07 W=7.6e-07 $X=1260 $Y=590 $dt=0
M3 VSS A 4 1 nfet_01v8 L=1.5e-07 W=7.6e-07 $X=1690 $Y=590 $dt=0
M4 4 B Y 1 nfet_01v8 L=1.5e-07 W=7.6e-07 $X=2120 $Y=590 $dt=0
M5 Y B 4 1 nfet_01v8 L=1.5e-07 W=7.6e-07 $X=2550 $Y=590 $dt=0
M6 4 B Y 1 nfet_01v8 L=1.5e-07 W=7.6e-07 $X=2980 $Y=590 $dt=0
M7 Y B 4 1 nfet_01v8 L=1.5e-07 W=7.6e-07 $X=3410 $Y=590 $dt=0
M8 VDD A Y 2 pfet_01v8 L=1.5e-07 W=1.13e-06 $X=400 $Y=2420 $dt=1
M9 Y A VDD 2 pfet_01v8 L=1.5e-07 W=1.13e-06 $X=830 $Y=2420 $dt=1
M10 VDD A Y 2 pfet_01v8 L=1.5e-07 W=1.13e-06 $X=1260 $Y=2420 $dt=1
M11 Y A VDD 2 pfet_01v8 L=1.5e-07 W=1.13e-06 $X=1690 $Y=2420 $dt=1
M12 VDD B Y 2 pfet_01v8 L=1.5e-07 W=1.13e-06 $X=2120 $Y=2420 $dt=1
M13 Y B VDD 2 pfet_01v8 L=1.5e-07 W=1.13e-06 $X=2550 $Y=2420 $dt=1
M14 VDD B Y 2 pfet_01v8 L=1.5e-07 W=1.13e-06 $X=2980 $Y=2420 $dt=1
M15 Y B VDD 2 pfet_01v8 L=1.5e-07 W=1.13e-06 $X=3410 $Y=2420 $dt=1
** N=75 EP=7 NDC=16 FDC=16 HDC=16
.ends NAND2X4

* +++++++++++++++++++++++++++++++++++++++++++++++++++++
* Sub cell: OR2X2
* +++++++++++++++++++++++++++++++++++++++++++++++++++++
.subckt OR2X2 1 2 VSS Y B A VDD
M0 VSS B 4 1 nfet_01v8 L=1.5e-07 W=4.25e-07 $X=400 $Y=590 $dt=0
M1 4 A VSS 1 nfet_01v8 L=1.5e-07 W=4.25e-07 $X=830 $Y=590 $dt=0
M2 VSS 4 Y 1 nfet_01v8 L=1.5e-07 W=7.6e-07 $X=1320 $Y=590 $dt=0
M3 Y 4 VSS 1 nfet_01v8 L=1.5e-07 W=7.6e-07 $X=1750 $Y=590 $dt=0
M4 4 B 9 2 pfet_01v8 L=1.5e-07 W=6.25e-07 $X=400 $Y=2925 $dt=1
M5 VDD A 9 2 pfet_01v8 L=1.5e-07 W=6.25e-07 $X=830 $Y=2925 $dt=1
M6 VDD 4 Y 2 pfet_01v8 L=1.5e-07 W=1.13e-06 $X=1320 $Y=2420 $dt=1
M7 Y 4 VDD 2 pfet_01v8 L=1.5e-07 W=1.13e-06 $X=1750 $Y=2420 $dt=1
** N=40 EP=7 NDC=8 FDC=8 HDC=8
.ends OR2X2

* +++++++++++++++++++++++++++++++++++++++++++++++++++++
* Sub cell: MX2X1
* +++++++++++++++++++++++++++++++++++++++++++++++++++++
.subckt MX2X1 1 2 VSS Y A B S0 VDD
M0 5 S0 VSS 1 nfet_01v8 L=1.5e-07 W=4.25e-07 $X=400 $Y=590 $dt=0
M1 VSS A 13 1 nfet_01v8 L=1.5e-07 W=4.25e-07 $X=830 $Y=590 $dt=0
M2 13 5 6 1 nfet_01v8 L=1.5e-07 W=4.25e-07 $X=1260 $Y=590 $dt=0
M3 6 S0 14 1 nfet_01v8 L=1.5e-07 W=4.25e-07 $X=1690 $Y=590 $dt=0
M4 14 B VSS 1 nfet_01v8 L=1.5e-07 W=4.25e-07 $X=2120 $Y=590 $dt=0
M5 VSS 6 Y 1 nfet_01v8 L=1.5e-07 W=7.6e-07 $X=2610 $Y=590 $dt=0
M6 5 S0 VDD 2 pfet_01v8 L=1.5e-07 W=6.25e-07 $X=400 $Y=2925 $dt=1
M7 VDD A 11 2 pfet_01v8 L=1.5e-07 W=6.25e-07 $X=830 $Y=2925 $dt=1
M8 11 S0 6 2 pfet_01v8 L=1.5e-07 W=6.25e-07 $X=1260 $Y=2925 $dt=1
M9 6 5 12 2 pfet_01v8 L=1.5e-07 W=6.25e-07 $X=1690 $Y=2925 $dt=1
M10 VDD B 12 2 pfet_01v8 L=1.5e-07 W=6.25e-07 $X=2120 $Y=2925 $dt=1
M11 VDD 6 Y 2 pfet_01v8 L=1.5e-07 W=1.13e-06 $X=2610 $Y=2420 $dt=1
** N=55 EP=8 NDC=12 FDC=12 HDC=12
.ends MX2X1

* +++++++++++++++++++++++++++++++++++++++++++++++++++++
* Sub cell: OAI22X1
* +++++++++++++++++++++++++++++++++++++++++++++++++++++
.subckt OAI22X1 1 2 VSS Y A0 B1 A1 B0 VDD
M0 4 A0 VSS 1 nfet_01v8 L=1.5e-07 W=7.6e-07 $X=400 $Y=590 $dt=0
M1 VSS A1 4 1 nfet_01v8 L=1.5e-07 W=7.6e-07 $X=830 $Y=590 $dt=0
M2 4 B1 Y 1 nfet_01v8 L=1.5e-07 W=7.6e-07 $X=1260 $Y=590 $dt=0
M3 Y B0 4 1 nfet_01v8 L=1.5e-07 W=7.6e-07 $X=1690 $Y=590 $dt=0
M4 VDD A0 11 2 pfet_01v8 L=1.5e-07 W=1.13e-06 $X=400 $Y=2420 $dt=1
M5 11 A1 Y 2 pfet_01v8 L=1.5e-07 W=1.13e-06 $X=830 $Y=2420 $dt=1
M6 Y B1 12 2 pfet_01v8 L=1.5e-07 W=1.13e-06 $X=1260 $Y=2420 $dt=1
M7 12 B0 VDD 2 pfet_01v8 L=1.5e-07 W=1.13e-06 $X=1690 $Y=2420 $dt=1
** N=51 EP=9 NDC=8 FDC=8 HDC=8
.ends OAI22X1

* +++++++++++++++++++++++++++++++++++++++++++++++++++++
* Sub cell: OAI211X1_HS
* +++++++++++++++++++++++++++++++++++++++++++++++++++++
.subckt OAI211X1_HS 1 2 VSS Y A0 B0 A1 C0 VDD
M0 VDD A0 11 2 pfet_01v8 L=1.5e-07 W=1.46e-06 $X=860 $Y=2285 $dt=1
M1 11 A1 Y 2 pfet_01v8 L=1.5e-07 W=1.46e-06 $X=1290 $Y=2285 $dt=1
M2 Y B0 VDD 2 pfet_01v8 L=1.5e-07 W=1.46e-06 $X=1720 $Y=2285 $dt=1
M3 VDD C0 Y 2 pfet_01v8 L=1.5e-07 W=1.46e-06 $X=2150 $Y=2285 $dt=1
M4 4 A0 VSS 1 nfet_01v8_lvt L=1.5e-07 W=7.6e-07 $X=860 $Y=395 $dt=3
M5 VSS A1 4 1 nfet_01v8_lvt L=1.5e-07 W=7.6e-07 $X=1290 $Y=395 $dt=3
M6 4 B0 12 1 nfet_01v8_lvt L=1.5e-07 W=7.6e-07 $X=1720 $Y=395 $dt=3
M7 12 C0 Y 1 nfet_01v8_lvt L=1.5e-07 W=7.6e-07 $X=2150 $Y=395 $dt=3
** N=57 EP=9 NDC=8 FDC=8 HDC=8
.ends OAI211X1_HS

* +++++++++++++++++++++++++++++++++++++++++++++++++++++
* Sub cell: OAI21X2_HS
* +++++++++++++++++++++++++++++++++++++++++++++++++++++
.subckt OAI21X2_HS 1 2 VSS Y A0 B0 A1 VDD
M0 VDD A0 9 2 pfet_01v8 L=1.5e-07 W=1.46e-06 $X=860 $Y=2285 $dt=1
M1 9 A0 VDD 2 pfet_01v8 L=1.5e-07 W=1.46e-06 $X=1290 $Y=2285 $dt=1
M2 VDD B0 Y 2 pfet_01v8 L=1.5e-07 W=1.46e-06 $X=1720 $Y=2285 $dt=1
M3 Y B0 VDD 2 pfet_01v8 L=1.5e-07 W=1.46e-06 $X=2150 $Y=2285 $dt=1
M4 Y A1 9 2 pfet_01v8 L=1.5e-07 W=1.46e-06 $X=3100 $Y=2285 $dt=1
M5 9 A1 Y 2 pfet_01v8 L=1.5e-07 W=1.46e-06 $X=3530 $Y=2285 $dt=1
M6 4 A0 VSS 1 nfet_01v8_lvt L=1.5e-07 W=7.6e-07 $X=860 $Y=395 $dt=3
M7 VSS A0 4 1 nfet_01v8_lvt L=1.5e-07 W=7.6e-07 $X=1290 $Y=395 $dt=3
M8 4 B0 Y 1 nfet_01v8_lvt L=1.5e-07 W=7.6e-07 $X=1720 $Y=395 $dt=3
M9 Y B0 4 1 nfet_01v8_lvt L=1.5e-07 W=7.6e-07 $X=2150 $Y=395 $dt=3
M10 4 A1 VSS 1 nfet_01v8_lvt L=1.5e-07 W=7.6e-07 $X=3100 $Y=395 $dt=3
M11 VSS A1 4 1 nfet_01v8_lvt L=1.5e-07 W=7.6e-07 $X=3530 $Y=395 $dt=3
** N=82 EP=8 NDC=12 FDC=12 HDC=12
.ends OAI21X2_HS

* +++++++++++++++++++++++++++++++++++++++++++++++++++++
* Sub cell: AND2X2
* +++++++++++++++++++++++++++++++++++++++++++++++++++++
.subckt AND2X2 1 2 VSS Y A B VDD
M0 4 B 9 1 nfet_01v8 L=1.5e-07 W=4.25e-07 $X=400 $Y=590 $dt=0
M1 9 A VSS 1 nfet_01v8 L=1.5e-07 W=4.25e-07 $X=830 $Y=590 $dt=0
M2 VSS 4 Y 1 nfet_01v8 L=1.5e-07 W=7.6e-07 $X=1320 $Y=590 $dt=0
M3 Y 4 VSS 1 nfet_01v8 L=1.5e-07 W=7.6e-07 $X=1750 $Y=590 $dt=0
M4 VDD B 4 2 pfet_01v8 L=1.5e-07 W=6.25e-07 $X=400 $Y=2925 $dt=1
M5 VDD A 4 2 pfet_01v8 L=1.5e-07 W=6.25e-07 $X=830 $Y=2925 $dt=1
M6 VDD 4 Y 2 pfet_01v8 L=1.5e-07 W=1.13e-06 $X=1320 $Y=2420 $dt=1
M7 Y 4 VDD 2 pfet_01v8 L=1.5e-07 W=1.13e-06 $X=1750 $Y=2420 $dt=1
** N=40 EP=7 NDC=8 FDC=8 HDC=8
.ends AND2X2

* +++++++++++++++++++++++++++++++++++++++++++++++++++++
* Sub cell: BUFX8_HS
* +++++++++++++++++++++++++++++++++++++++++++++++++++++
.subckt BUFX8_HS 1 2 VSS Y A VDD
M0 VDD A 4 2 pfet_01v8 L=1.5e-07 W=1.46e-06 $X=860 $Y=2285 $dt=1
M1 4 A VDD 2 pfet_01v8 L=1.5e-07 W=1.46e-06 $X=1290 $Y=2285 $dt=1
M2 VDD 4 Y 2 pfet_01v8 L=1.5e-07 W=1.46e-06 $X=1720 $Y=2285 $dt=1
M3 Y 4 VDD 2 pfet_01v8 L=1.5e-07 W=1.46e-06 $X=2150 $Y=2285 $dt=1
M4 VDD 4 Y 2 pfet_01v8 L=1.5e-07 W=1.46e-06 $X=2580 $Y=2285 $dt=1
M5 Y 4 VDD 2 pfet_01v8 L=1.5e-07 W=1.46e-06 $X=3010 $Y=2285 $dt=1
M6 VDD 4 Y 2 pfet_01v8 L=1.5e-07 W=1.46e-06 $X=3440 $Y=2285 $dt=1
M7 Y 4 VDD 2 pfet_01v8 L=1.5e-07 W=1.46e-06 $X=3870 $Y=2285 $dt=1
M8 VDD 4 Y 2 pfet_01v8 L=1.5e-07 W=1.46e-06 $X=4300 $Y=2285 $dt=1
M9 Y 4 VDD 2 pfet_01v8 L=1.5e-07 W=1.46e-06 $X=4730 $Y=2285 $dt=1
M10 VSS A 4 1 nfet_01v8_lvt L=1.5e-07 W=7.6e-07 $X=860 $Y=395 $dt=3
M11 4 A VSS 1 nfet_01v8_lvt L=1.5e-07 W=7.6e-07 $X=1290 $Y=395 $dt=3
M12 VSS 4 Y 1 nfet_01v8_lvt L=1.5e-07 W=7.6e-07 $X=1720 $Y=395 $dt=3
M13 Y 4 VSS 1 nfet_01v8_lvt L=1.5e-07 W=7.6e-07 $X=2150 $Y=395 $dt=3
M14 VSS 4 Y 1 nfet_01v8_lvt L=1.5e-07 W=7.6e-07 $X=2580 $Y=395 $dt=3
M15 Y 4 VSS 1 nfet_01v8_lvt L=1.5e-07 W=7.6e-07 $X=3010 $Y=395 $dt=3
M16 VSS 4 Y 1 nfet_01v8_lvt L=1.5e-07 W=7.6e-07 $X=3440 $Y=395 $dt=3
M17 Y 4 VSS 1 nfet_01v8_lvt L=1.5e-07 W=7.6e-07 $X=3870 $Y=395 $dt=3
M18 VSS 4 Y 1 nfet_01v8_lvt L=1.5e-07 W=7.6e-07 $X=4300 $Y=395 $dt=3
M19 Y 4 VSS 1 nfet_01v8_lvt L=1.5e-07 W=7.6e-07 $X=4730 $Y=395 $dt=3
** N=104 EP=6 NDC=20 FDC=20 HDC=20
.ends BUFX8_HS

* +++++++++++++++++++++++++++++++++++++++++++++++++++++
* Sub cell: DFFX4_HS
* +++++++++++++++++++++++++++++++++++++++++++++++++++++
.subckt DFFX4_HS 1 2 VSS Q QN D CK VDD
M0 7 CK VDD 2 pfet_01v8 L=1.5e-07 W=7.8e-07 $X=860 $Y=2965 $dt=1
M1 VDD D 16 2 pfet_01v8 L=1.5e-07 W=7.8e-07 $X=1290 $Y=2965 $dt=1
M2 16 13 8 2 pfet_01v8 L=1.5e-07 W=7.8e-07 $X=1720 $Y=2965 $dt=1
M3 8 7 17 2 pfet_01v8 L=1.5e-07 W=7.8e-07 $X=2150 $Y=2965 $dt=1
M4 17 9 VDD 2 pfet_01v8 L=1.5e-07 W=7.8e-07 $X=2580 $Y=2965 $dt=1
M5 VDD 7 13 2 pfet_01v8 L=1.5e-07 W=7.8e-07 $X=3010 $Y=2965 $dt=1
M6 VDD 8 9 2 pfet_01v8 L=1.5e-07 W=7.8e-07 $X=3960 $Y=2965 $dt=1
M7 9 7 10 2 pfet_01v8 L=1.5e-07 W=7.8e-07 $X=4390 $Y=2965 $dt=1
M8 10 13 18 2 pfet_01v8 L=1.5e-07 W=7.8e-07 $X=4820 $Y=2965 $dt=1
M9 VDD 11 18 2 pfet_01v8 L=1.5e-07 W=7.8e-07 $X=5250 $Y=2965 $dt=1
M10 VDD 10 11 2 pfet_01v8 L=1.5e-07 W=1.12e-06 $X=5740 $Y=2625 $dt=1
M11 11 10 VDD 2 pfet_01v8 L=1.5e-07 W=1.12e-06 $X=6170 $Y=2625 $dt=1
M12 4 11 VDD 2 pfet_01v8 L=1.5e-07 W=1.46e-06 $X=7120 $Y=2285 $dt=1
M13 VDD 11 Q 2 pfet_01v8 L=1.5e-07 W=1.46e-06 $X=7550 $Y=2285 $dt=1
M14 Q 11 VDD 2 pfet_01v8 L=1.5e-07 W=1.46e-06 $X=7980 $Y=2285 $dt=1
M15 VDD 11 Q 2 pfet_01v8 L=1.5e-07 W=1.46e-06 $X=8410 $Y=2285 $dt=1
M16 Q 11 VDD 2 pfet_01v8 L=1.5e-07 W=1.46e-06 $X=8840 $Y=2285 $dt=1
M17 VDD 4 QN 2 pfet_01v8 L=1.5e-07 W=1.46e-06 $X=9270 $Y=2285 $dt=1
M18 QN 4 VDD 2 pfet_01v8 L=1.5e-07 W=1.46e-06 $X=9700 $Y=2285 $dt=1
M19 VDD 4 QN 2 pfet_01v8 L=1.5e-07 W=1.46e-06 $X=10130 $Y=2285 $dt=1
M20 QN 4 VDD 2 pfet_01v8 L=1.5e-07 W=1.46e-06 $X=10560 $Y=2285 $dt=1
M21 7 CK VSS 1 nfet_01v8_lvt L=1.5e-07 W=4.25e-07 $X=860 $Y=395 $dt=3
M22 VSS D 19 1 nfet_01v8_lvt L=1.5e-07 W=4.25e-07 $X=1290 $Y=395 $dt=3
M23 19 7 8 1 nfet_01v8_lvt L=1.5e-07 W=4.25e-07 $X=1720 $Y=395 $dt=3
M24 8 13 20 1 nfet_01v8_lvt L=1.5e-07 W=4.25e-07 $X=2150 $Y=395 $dt=3
M25 20 9 VSS 1 nfet_01v8_lvt L=1.5e-07 W=4.25e-07 $X=2580 $Y=395 $dt=3
M26 VSS 7 13 1 nfet_01v8_lvt L=1.5e-07 W=4.25e-07 $X=3010 $Y=395 $dt=3
M27 VSS 8 9 1 nfet_01v8_lvt L=1.5e-07 W=4.25e-07 $X=3960 $Y=395 $dt=3
M28 9 13 10 1 nfet_01v8_lvt L=1.5e-07 W=4.25e-07 $X=4390 $Y=395 $dt=3
M29 10 7 21 1 nfet_01v8_lvt L=1.5e-07 W=4.25e-07 $X=4820 $Y=395 $dt=3
M30 21 11 VSS 1 nfet_01v8_lvt L=1.5e-07 W=4.25e-07 $X=5250 $Y=395 $dt=3
M31 VSS 10 11 1 nfet_01v8_lvt L=1.5e-07 W=6e-07 $X=5740 $Y=395 $dt=3
M32 11 10 VSS 1 nfet_01v8_lvt L=1.5e-07 W=6e-07 $X=6170 $Y=395 $dt=3
M33 4 11 VSS 1 nfet_01v8_lvt L=1.5e-07 W=7.6e-07 $X=7120 $Y=395 $dt=3
M34 VSS 11 Q 1 nfet_01v8_lvt L=1.5e-07 W=7.6e-07 $X=7550 $Y=395 $dt=3
M35 Q 11 VSS 1 nfet_01v8_lvt L=1.5e-07 W=7.6e-07 $X=7980 $Y=395 $dt=3
M36 VSS 11 Q 1 nfet_01v8_lvt L=1.5e-07 W=7.6e-07 $X=8410 $Y=395 $dt=3
M37 Q 11 VSS 1 nfet_01v8_lvt L=1.5e-07 W=7.6e-07 $X=8840 $Y=395 $dt=3
M38 VSS 4 QN 1 nfet_01v8_lvt L=1.5e-07 W=7.6e-07 $X=9270 $Y=395 $dt=3
M39 QN 4 VSS 1 nfet_01v8_lvt L=1.5e-07 W=7.6e-07 $X=9700 $Y=395 $dt=3
M40 VSS 4 QN 1 nfet_01v8_lvt L=1.5e-07 W=7.6e-07 $X=10130 $Y=395 $dt=3
M41 QN 4 VSS 1 nfet_01v8_lvt L=1.5e-07 W=7.6e-07 $X=10560 $Y=395 $dt=3
** N=192 EP=8 NDC=42 FDC=42 HDC=42
.ends DFFX4_HS

* +++++++++++++++++++++++++++++++++++++++++++++++++++++
* Sub cell: chip_top
* +++++++++++++++++++++++++++++++++++++++++++++++++++++
.subckt chip_top VSS: wdata_i[27] addr_i[5] addr_i[7] addr_i[11] rst_i addr_i[8] halt_cpu_i en_cpu_i addr_i[10]
+ addr_i[9] addr_i[13] addr_i[12] r_en_i w_en_i addr_i[6] addr_i[4] cpu_halted_o wdata_i[10] rready_o
+ addr_i[2] addr_i[3] wdata_i[18] wdata_i[23] wdata_i[12] rdata_o[5] wdata_i[4] wdata_i[9] wdata_i[13] wdata_i[1]
+ wdata_i[8] wdata_i[14] wdata_i[11] wdata_i[16] wdata_i[15] wdata_i[2] wdata_i[3] wdata_i[6] wdata_i[5] wdata_i[17]
+ wdata_i[29] wdata_i[0] wdata_i[7] rdata_o[12] wdata_i[22] wdata_i[26] wdata_i[25] rdata_o[16] rdata_o[23] wdata_i[20]
+ wdata_i[19] wdata_i[21] wdata_i[24] wdata_i[28] rdata_o[4] rdata_o[8] wdata_i[30] rdata_o[9] wdata_i[31] rdata_o[6]
+ rdata_o[11] rdata_o[25] rdata_o[13] rdata_o[18] rdata_o[0] rdata_o[3] rdata_o[7] rdata_o[14] clk_i rdata_o[21]
+ rdata_o[10] rdata_o[1] rdata_o[2] rdata_o[30] rdata_o[26] rdata_o[17] rdata_o[31] rdata_o[27] rdata_o[19] rdata_o[20]
+ rdata_o[28] rdata_o[24] rdata_o[29] rdata_o[22] rdata_o[15] addr_i[1] addr_i[0]
X853 VSS: 2 VSS: 140 141 2 CLKINVX2 $T=32200 46920 1 180 $X=30640 $Y=46655
X904 VSS: 2 VSS: 143 144 2 CLKBUFX2 $T=28980 88320 0 0 $X=28800 $Y=88055
X905 VSS: 2 VSS: 145 143 2 CLKINVX2 $T=31280 88320 0 0 $X=31100 $Y=88055
X911 VSS: 2 VSS: 146 144 2 BUFX16_HS $T=35880 96600 0 180 $X=25580 $Y=92155
X917 VSS: 2 VSS: 307 301 275 2 NAND2X4 $T=32200 96600 0 0 $X=32020 $Y=96335
X922 VSS: 2 VSS: 148 147 2 BUFX2 $T=30820 104880 0 180 $X=28340 $Y=100435
X924 VSS: 2 VSS: 275 147 2 INVX4_HS $T=32660 104880 1 0 $X=32480 $Y=100435
X935 VSS: 2 VSS: 150 149 2 BUFX2 $T=31740 113160 0 180 $X=29260 $Y=108715
X942 VSS: 2 VSS: 151 150 153 152 2 NAND3X4_HS $T=34500 113160 1 180 $X=27420 $Y=112895
X947 VSS: 2 VSS: 154 206 2 BUFX8_HS $T=34500 121440 0 180 $X=28800 $Y=116995
X951 VSS: 2 VSS: 157 156 140 148 155 2 OAI22X1_HS $T=28060 121440 0 0 $X=27880 $Y=121175
X957 VSS: 2 VSS: 160 158 159 157 2 OAI21X1_HS $T=28520 129720 1 0 $X=28340 $Y=125275
X963 VSS: 2 VSS: 161 160 2 CLKBUFX2_HS $T=28520 129720 0 0 $X=28340 $Y=129455
X971 VSS: 2 VSS: 162 297 161 2 NAND2X4_HS $T=36340 138000 0 180 $X=31100 $Y=133555
X976 VSS: 2 VSS: 152 164 2 BUFX2_HS $T=25760 138000 0 0 $X=25580 $Y=137735
X978 VSS: 2 VSS: 164 163 165 2 NAND2X2_HS $T=32200 138000 1 180 $X=28800 $Y=137735
X984 VSS: 2 VSS: 166 147 2 CLKBUFX2_HS $T=25760 146280 1 0 $X=25580 $Y=141835
X988 VSS: 2 VSS: 177 326 154 2 NAND2X4 $T=36340 146280 0 180 $X=32020 $Y=141835
X993 VSS: 2 VSS: 165 166 2 INVX8_HS $T=32200 146280 1 180 $X=26960 $Y=146015
X999 VSS: 2 VSS: 168 167 154 2 NAND2X4_HS $T=31740 154560 0 180 $X=26500 $Y=150115
X1005 VSS: 2 VSS: 169 170 146 2 NAND2X2 $T=30820 154560 1 180 $X=28340 $Y=154295
X1012 VSS: 2 VSS: 171 168 169 164 172 2 NAND4X2_HS $T=27600 162840 1 0 $X=27420 $Y=158395
X1018 VSS: 2 VSS: 173 171 2 INVX2_HS $T=29440 162840 0 0 $X=29260 $Y=162575
X1023 VSS: 2 VSS: 174 177 169 175 176 2 NAND4X2_HS $T=33580 171120 0 180 $X=27880 $Y=166675
X1028 VSS: 2 VSS: 175 178 165 2 NAND2X4 $T=33120 171120 1 180 $X=28800 $Y=170855
X1033 VSS: 2 VSS: 179 168 2 BUFX2 $T=27140 179400 1 0 $X=26960 $Y=174955
X1036 VSS: 2 VSS: 348 193 182 179 183 2 NAND4X4_HS $T=40480 179400 0 180 $X=31560 $Y=174955
X1041 VSS: 2 VSS: 176 167 141 2 NAND2X2_HS $T=33120 179400 1 180 $X=29720 $Y=179135
X1047 VSS: 2 VSS: 180 170 165 2 NAND2X2 $T=30360 187680 1 0 $X=30180 $Y=183235
X1053 VSS: 2 VSS: 182 181 165 2 NAND2X2 $T=30820 187680 1 180 $X=28340 $Y=187415
X1058 VSS: 2 VSS: 185 147 2 INVX4 $T=27600 195960 0 180 $X=25120 $Y=191515
X1061 VSS: 2 VSS: 352 180 184 183 176 2 NAND4X4_HS $T=37720 195960 0 180 $X=28800 $Y=191515
X1065 VSS: 2 VSS: 189 184 188 187 186 2 NAND4X4_HS $T=32200 195960 1 180 $X=23280 $Y=195695
X1071 VSS: 2 VSS: 187 181 146 2 NAND2X4_HS $T=32200 204240 0 180 $X=26960 $Y=199795
X1076 VSS: 2 VSS: 188 191 185 2 NAND2X2 $T=27140 204240 1 180 $X=24660 $Y=203975
X1079 VSS: 2 VSS: 186 192 190 2 NAND2X1_HS $T=32200 204240 1 180 $X=29720 $Y=203975
X1086 VSS: 2 VSS: 195 193 187 175 194 2 NAND4X2_HS $T=33120 212520 0 180 $X=27420 $Y=208075
X1092 VSS: 2 VSS: 196 191 146 2 NAND2X2 $T=27600 212520 0 0 $X=27420 $Y=212255
X1095 VSS: 2 VSS: 194 192 206 2 NAND2X2 $T=34500 212520 1 180 $X=32020 $Y=212255
X1100 VSS: 2 VSS: 198 196 186 2 NAND2X2_HS $T=28520 220800 1 0 $X=28340 $Y=216355
X1105 VSS: 2 VSS: 200 197 199 196 194 2 NAND4X4_HS $T=33120 220800 1 180 $X=24200 $Y=220535
X1110 VSS: 2 VSS: 203 188 201 202 197 2 NAND4X4 $T=23920 229080 1 0 $X=23740 $Y=224635
X1116 VSS: 2 VSS: 202 204 146 2 NAND2X2_HS $T=25760 229080 0 0 $X=25580 $Y=228815
X1118 VSS: 2 VSS: 375 365 373 202 205 2 NAND4X4_HS $T=41400 229080 1 180 $X=32480 $Y=228815
X1123 VSS: 2 VSS: 205 156 141 2 NAND2X4_HS $T=34040 237360 0 180 $X=28800 $Y=232915
X1128 VSS: 2 VSS: 199 204 185 2 NAND2X1_HS $T=25760 237360 0 0 $X=25580 $Y=237095
X1132 VSS: 2 VSS: 201 156 206 2 NAND2X2 $T=33580 237360 1 180 $X=31100 $Y=237095
X1136 VSS: 2 VSS: 209 207 205 199 208 2 NAND4X2_HS $T=25300 245640 1 0 $X=25120 $Y=241195
X1142 VSS: 2 VSS: 207 210 206 2 NAND2X1 $T=29900 245640 1 180 $X=27880 $Y=245375
X1148 VSS: 2 VSS: 212 211 185 2 NAND2X1 $T=30360 253920 0 180 $X=28340 $Y=249475
X1154 VSS: 2 VSS: 213 207 212 2 AND2X1_HS $T=29440 253920 1 180 $X=26500 $Y=253655
X1158 VSS: 2 VSS: 373 155 185 2 NAND2X4_HS $T=37720 253920 1 180 $X=32480 $Y=253655
X1162 VSS: 2 VSS: 214 213 215 2 NAND2X4_HS $T=26220 262200 1 0 $X=26040 $Y=257755
X1168 VSS: 2 VSS: 215 216 5 2 AND2X2_HS $T=32200 262200 1 180 $X=28800 $Y=261935
X1174 VSS: 2 VSS: 217 195 2 BUFX4_HS $T=32200 270480 0 180 $X=28340 $Y=266035
X1192 VSS: 2 VSS: 218 173 2 CLKINVX1 $T=30820 278760 0 0 $X=30640 $Y=278495
X1198 VSS: 2 VSS: 219 173 2 BUFX4_HS $T=32200 287040 0 180 $X=28340 $Y=282595
X1225 VSS: 2 VSS: 405 406 2 BUFX16_HS $T=42780 303600 1 180 $X=32480 $Y=303335
X1235 VSS: 2 VSS: 413 412 2 BUFX16_HS $T=38640 311880 1 180 $X=28340 $Y=311615
X1242 VSS: 2 VSS: 412 416 2 CLKINVX2_HS $T=34960 320160 0 180 $X=31100 $Y=315715
X1248 VSS: 2 VSS: 420 418 2 BUFX16_HS $T=40480 320160 1 180 $X=30180 $Y=319895
X1263 VSS: 2 VSS: 221 17 220 2 NAND2X2_HS $T=29900 336720 0 180 $X=26500 $Y=332275
X1268 VSS: 2 VSS: 220 222 27 2 NAND2X2_HS $T=25300 336720 0 0 $X=25120 $Y=336455
X1273 VSS: 2 VSS: 226 224 223 2 NAND2X4_HS $T=29440 345000 0 180 $X=24200 $Y=340555
X1277 VSS: 2 VSS: 433 225 2 BUFX8_HS $T=32660 345000 1 0 $X=32480 $Y=340555
X1280 VSS: 2 VSS: 225 228 227 229 226 2 OAI211X2_HS $T=29900 345000 1 180 $X=24200 $Y=344735
X1289 VSS: 2 VSS: 229 230 222 27 2 AOI21X2_HS $T=28980 353280 1 180 $X=24200 $Y=353015
X1295 VSS: 2 VSS: 227 233 232 231 27 2 OAI211X1_HS $T=28060 361560 0 180 $X=24660 $Y=357115
X1302 VSS: 2 VSS: 232 231 233 222 2 OAI21X1 $T=25760 361560 0 0 $X=25580 $Y=361295
X1307 VSS: 2 VSS: 238 234 2 INVX1 $T=18400 369840 1 0 $X=18220 $Y=365395
X1308 VSS: 2 VSS: 235 239 238 2 NAND2X1 $T=19780 369840 1 0 $X=19600 $Y=365395
X1310 VSS: 2 VSS: 237 235 236 2 CLKXOR2X1 $T=22080 369840 1 0 $X=21900 $Y=365395
X1313 VSS: 2 VSS: 224 33 237 2 AND2X1 $T=26680 369840 1 0 $X=26500 $Y=365395
X1316 VSS: 2 VSS: 240 233 231 2 NAND2X1 $T=31280 369840 1 0 $X=31100 $Y=365395
X1318 VSS: 2 VSS: 242 234 239 236 2 OAI21X2_HS $T=17940 369840 0 0 $X=17760 $Y=369575
X1320 VSS: 2 VSS: 234 241 231 2 NOR2X1 $T=25300 369840 1 180 $X=23280 $Y=369575
X1321 VSS: 2 VSS: 239 231 241 2 NAND2X1 $T=25300 369840 0 0 $X=25120 $Y=369575
X1324 VSS: 2 VSS: 243 222 240 2 NOR2X1 $T=31740 369840 1 180 $X=29720 $Y=369575
X1329 VSS: 2 VSS: 245 243 27 244 2 NAND3X1 $T=28520 378120 0 180 $X=26040 $Y=373675
X1335 VSS: 2 VSS: 248 244 245 247 246 2 OAI211X2_HS $T=30820 378120 1 180 $X=25120 $Y=377855
X1339 VSS: 2 VSS: 247 230 249 27 2 AOI21X2_HS $T=25300 386400 0 180 $X=20520 $Y=381955
X1341 VSS: 2 VSS: 249 243 2 INVX1 $T=28520 386400 0 180 $X=26960 $Y=381955
X1346 VSS: 2 VSS: 256 254 251 249 2 OAI21X1 $T=21620 386400 1 180 $X=19140 $Y=386135
X1349 VSS: 2 VSS: 255 250 253 247 252 2 OAI211X2_HS $T=32660 386400 1 180 $X=26960 $Y=386135
X1353 VSS: 2 VSS: 253 251 256 254 27 2 OAI211X1_HS $T=18400 394680 1 0 $X=18220 $Y=390235
X1357 VSS: 2 VSS: 17 230 2 INVX1 $T=30820 394680 1 0 $X=30640 $Y=390235
X1362 VSS: 2 VSS: 246 258 223 2 NAND2X1 $T=28060 394680 1 180 $X=26040 $Y=394415
X1364 VSS: 2 VSS: 252 257 223 2 NAND2X1_HS $T=29900 394680 0 0 $X=29720 $Y=394415
X1368 VSS: 2 VSS: 261 242 2 CLKBUFX2 $T=18400 402960 1 0 $X=18220 $Y=398515
X1369 VSS: 2 VSS: 260 261 259 2 XNOR2X1 $T=20700 402960 1 0 $X=20520 $Y=398515
X1371 VSS: 2 VSS: 258 33 260 2 AND2X1 $T=26220 402960 1 0 $X=26040 $Y=398515
X1375 VSS: 2 VSS: 264 251 262 2 NAND2X1 $T=19320 402960 1 180 $X=17300 $Y=402695
X1378 VSS: 2 VSS: 259 264 263 2 NAND2X1 $T=22080 402960 0 0 $X=21900 $Y=402695
X1381 VSS: 2 VSS: 263 262 251 2 OR2X1 $T=27600 402960 1 180 $X=25120 $Y=402695
X1385 VSS: 2 VSS: 266 264 2 INVX1 $T=17940 411240 1 0 $X=17760 $Y=406795
X1387 VSS: 2 VSS: 267 266 242 263 2 AOI21X2_HS $T=20240 411240 1 0 $X=20060 $Y=406795
X1391 VSS: 2 VSS: 265 254 251 2 AND2X1 $T=28060 411240 1 0 $X=27880 $Y=406795
X1397 VSS: 2 VSS: 269 268 267 2 CLKXOR2X1 $T=27140 411240 0 0 $X=26960 $Y=410975
X1399 VSS: 2 VSS: 268 476 477 2 NAND2X1 $T=34040 411240 1 180 $X=32020 $Y=410975
X1404 VSS: 2 VSS: 257 33 269 2 AND2X1 $T=28980 419520 1 0 $X=28800 $Y=415075
X1702 VSS: 2 VSS: 273 272 271 2 NAND2X2 $T=44160 30360 0 180 $X=41680 $Y=25915
X1710 VSS: 2 VSS: 277 274 275 2 NAND2X2 $T=43240 30360 1 180 $X=40760 $Y=30095
X1716 VSS: 2 VSS: 278 272 275 2 NAND2X1 $T=43240 38640 0 180 $X=41220 $Y=34195
X1725 VSS: 2 VSS: 282 278 279 280 281 2 NAND4X1 $T=43240 38640 1 180 $X=40300 $Y=38375
X1731 VSS: 2 VSS: 283 284 276 2 NAND2X2_HS $T=45080 46920 0 180 $X=41680 $Y=42475
X1740 VSS: 2 VSS: 279 284 141 2 NAND2X4_HS $T=45080 46920 1 180 $X=39840 $Y=46655
X1745 VSS: 2 VSS: 286 279 273 277 285 2 NAND4X4_HS $T=46460 55200 0 180 $X=37540 $Y=50755
X1752 VSS: 2 VSS: 288 287 270 2 NAND2X1 $T=36800 55200 1 180 $X=34780 $Y=54935
X1757 VSS: 2 VSS: 285 287 276 2 NAND2X4 $T=50600 55200 1 180 $X=46280 $Y=54935
X1762 VSS: 2 VSS: 290 289 288 283 273 2 NAND4X1 $T=42320 63480 1 0 $X=42140 $Y=59035
X1771 VSS: 2 VSS: 289 291 275 2 NAND2X2 $T=41860 63480 0 0 $X=41680 $Y=63215
X1776 VSS: 2 VSS: 294 292 275 2 NAND2X2 $T=38180 71760 1 0 $X=38000 $Y=67315
X1780 VSS: 2 VSS: 507 293 2 CLKINVX2 $T=48760 71760 1 0 $X=48580 $Y=67315
X1785 VSS: 2 VSS: 296 295 293 2 NOR2X2_HS $T=37260 71760 0 0 $X=37080 $Y=71495
X1791 VSS: 2 VSS: 295 297 2 CLKINVX2 $T=34960 80040 1 0 $X=34780 $Y=75595
X1796 VSS: 2 VSS: 512 295 510 2 NOR2X4_HS $T=48300 80040 1 0 $X=48120 $Y=75595
X1807 VSS: 2 VSS: 298 297 293 2 NAND2X2 $T=41860 88320 1 0 $X=41680 $Y=83875
X1814 VSS: 2 VSS: 299 144 2 BUFX4_HS $T=33120 88320 0 0 $X=32940 $Y=88055
X1816 VSS: 2 VSS: 271 144 2 BUFX8 $T=37260 88320 0 0 $X=37080 $Y=88055
X1819 VSS: 2 VSS: 300 301 141 2 NAND2X2 $T=47840 88320 0 0 $X=47660 $Y=88055
X1822 VSS: 2 VSS: 144 302 304 2 NOR2X4_HS $T=37260 96600 1 0 $X=37080 $Y=92155
X1825 VSS: 2 VSS: 304 303 2 CLKINVX2_HS $T=43700 96600 1 0 $X=43520 $Y=92155
X1827 VSS: 2 VSS: 518 309 275 2 NAND2X2 $T=51520 96600 0 180 $X=49040 $Y=92155
X1833 VSS: 2 VSS: 306 305 288 278 149 2 NAND4X2_HS $T=46000 96600 1 180 $X=40300 $Y=96335
X1837 VSS: 2 VSS: 519 306 2 INVX4_HS $T=49220 96600 0 0 $X=49040 $Y=96335
X1840 VSS: 2 VSS: 305 291 299 2 NAND2X1 $T=40480 104880 0 180 $X=38460 $Y=100435
X1841 VSS: 2 VSS: 308 310 305 285 307 2 NAND4X2_HS $T=46000 104880 0 180 $X=40300 $Y=100435
X1846 VSS: 2 VSS: 311 301 299 2 NAND2X2_HS $T=33580 104880 0 0 $X=33400 $Y=104615
X1850 VSS: 2 VSS: 312 311 310 2 AND2X1_HS $T=45540 104880 1 180 $X=42600 $Y=104615
X1854 VSS: 2 VSS: 153 313 311 2 CLKAND2X2 $T=36800 113160 0 180 $X=34320 $Y=108715
X1858 VSS: 2 VSS: 315 314 289 312 2 NAND3X2_HS $T=41860 113160 1 0 $X=41680 $Y=108715
X1860 VSS: 2 VSS: 528 315 2 CLKINVX2_HS $T=48300 113160 1 0 $X=48120 $Y=108715
X1865 VSS: 2 VSS: 313 190 309 2 NAND2X4_HS $T=35420 113160 0 0 $X=35240 $Y=112895
X1868 VSS: 2 VSS: 310 292 190 2 NAND2X4_HS $T=41860 113160 0 0 $X=41680 $Y=112895
X1873 VSS: 2 VSS: 149 292 154 2 NAND2X2_HS $T=37720 121440 1 0 $X=37540 $Y=116995
X1875 VSS: 2 VSS: 314 309 154 2 NAND2X2 $T=41400 121440 1 0 $X=41220 $Y=116995
X1876 VSS: 2 VSS: 317 206 2 CLKINVX2 $T=43700 121440 1 0 $X=43520 $Y=116995
X1879 VSS: 2 VSS: 316 509 2 INVX4 $T=50140 121440 0 180 $X=47660 $Y=116995
X1886 VSS: 2 VSS: 320 211 145 317 318 2 OAI22X1 $T=43240 121440 0 0 $X=43060 $Y=121175
X1888 VSS: 2 VSS: 158 321 145 317 210 2 OAI22X1 $T=37720 129720 0 180 $X=34780 $Y=125275
X1890 VSS: 2 VSS: 322 210 140 148 321 2 OAI22X1 $T=41400 129720 1 0 $X=41220 $Y=125275
X1894 VSS: 2 VSS: 537 320 159 322 2 OAI21X1 $T=49220 129720 1 0 $X=49040 $Y=125275
X1902 VSS: 2 VSS: 323 163 154 2 NAND2X4 $T=44620 129720 1 180 $X=40300 $Y=129455
X1903 VSS: 2 VSS: 163 538 2 BUFX8 $T=49680 129720 1 180 $X=44440 $Y=129455
X1906 VSS: 2 VSS: 325 163 271 2 NAND2X4 $T=42780 138000 0 180 $X=38460 $Y=133555
X1909 VSS: 2 VSS: 324 163 190 2 NAND2X2 $T=46920 138000 1 0 $X=46740 $Y=133555
X1915 VSS: 2 VSS: 328 313 307 325 177 2 NAND4X2_HS $T=43240 138000 1 180 $X=37540 $Y=137735
X1919 VSS: 2 VSS: 327 326 146 2 NAND2X1 $T=46460 138000 0 0 $X=46280 $Y=137735
X1923 VSS: 2 VSS: 319 326 165 2 NAND2X2 $T=37720 146280 1 0 $X=37540 $Y=141835
X1925 VSS: 2 VSS: 329 170 154 2 NAND2X2 $T=40480 146280 1 0 $X=40300 $Y=141835
X1928 VSS: 2 VSS: 330 328 2 BUFX8_HS $T=44160 146280 1 0 $X=43980 $Y=141835
X1932 VSS: 2 VSS: 331 180 172 314 325 2 NAND4X1 $T=35880 146280 0 0 $X=35700 $Y=146015
X1935 VSS: 2 VSS: 332 329 334 335 333 2 NAND4X4 $T=41400 146280 0 0 $X=41220 $Y=146015
X1937 VSS: 2 VSS: 172 190 326 2 NAND2X2_HS $T=35880 154560 1 0 $X=35700 $Y=150115
X1940 VSS: 2 VSS: 338 167 165 2 NAND2X1_HS $T=41400 154560 1 0 $X=41220 $Y=150115
X1941 VSS: 2 VSS: 335 167 146 2 NAND2X2 $T=43700 154560 1 0 $X=43520 $Y=150115
X1943 VSS: 2 VSS: 337 319 336 2 CLKAND2X2 $T=46920 154560 1 0 $X=46740 $Y=150115
X1950 VSS: 2 VSS: 339 206 2 BUFX4_HS $T=38640 154560 0 0 $X=38460 $Y=154295
X1953 VSS: 2 VSS: 336 178 339 2 NAND2X2 $T=46460 154560 0 0 $X=46280 $Y=154295
X1959 VSS: 2 VSS: 340 336 342 343 341 2 NAND4X4_HS $T=51520 162840 0 180 $X=42600 $Y=158395
X1964 VSS: 2 VSS: 333 178 270 2 NAND2X2 $T=41400 162840 1 180 $X=38920 $Y=162575
X1973 VSS: 2 VSS: 344 346 338 2 AND2X1_HS $T=42320 171120 1 0 $X=42140 $Y=166675
X1974 VSS: 2 VSS: 345 344 333 343 2 NAND3X2_HS $T=45080 171120 1 0 $X=44900 $Y=166675
X1980 VSS: 2 VSS: 183 178 271 2 NAND2X2 $T=40940 171120 1 180 $X=38460 $Y=170855
X1983 VSS: 2 VSS: 343 347 146 2 NAND2X2 $T=46460 171120 0 0 $X=46280 $Y=170855
X1986 VSS: 2 VSS: 341 181 270 2 NAND2X2 $T=46460 179400 0 180 $X=43980 $Y=174955
X1993 VSS: 2 VSS: 334 347 165 2 NAND2X2 $T=37720 179400 0 0 $X=37540 $Y=179135
X1998 VSS: 2 VSS: 559 341 350 349 334 2 AND4X2_HS $T=46920 179400 0 0 $X=46740 $Y=179135
X2001 VSS: 2 VSS: 342 192 165 2 NAND2X2 $T=41860 187680 1 0 $X=41680 $Y=183235
X2003 VSS: 2 VSS: 544 563 350 351 346 2 NAND4X4_HS $T=54740 187680 0 180 $X=45820 $Y=183235
X2007 VSS: 2 VSS: 184 347 339 2 NAND2X2_HS $T=37720 187680 1 180 $X=34320 $Y=187415
X2011 VSS: 2 VSS: 349 191 339 2 NAND2X2 $T=42780 187680 0 0 $X=42600 $Y=187415
X2014 VSS: 2 VSS: 350 192 146 2 NAND2X2 $T=49220 187680 0 0 $X=49040 $Y=187415
X2017 VSS: 2 VSS: 357 156 165 2 NAND2X1 $T=39100 195960 1 0 $X=38920 $Y=191515
X2019 VSS: 2 VSS: 356 352 2 INVX4 $T=41860 195960 1 0 $X=41680 $Y=191515
X2021 VSS: 2 VSS: 353 355 342 351 354 2 AND4X2_HS $T=45080 195960 1 0 $X=44900 $Y=191515
X2027 VSS: 2 VSS: 141 358 2 BUFX8_HS $T=39100 195960 1 180 $X=33400 $Y=195695
X2030 VSS: 2 VSS: 360 359 355 349 357 2 NAND4X4_HS $T=49220 195960 1 180 $X=40300 $Y=195695
X2032 VSS: 2 VSS: 190 358 2 BUFX8_HS $T=38640 204240 0 180 $X=32940 $Y=199795
X2033 VSS: 2 VSS: 270 358 2 BUFX8_HS $T=38640 204240 1 0 $X=38460 $Y=199795
X2036 VSS: 2 VSS: 355 361 146 2 NAND2X1_HS $T=47840 204240 0 180 $X=45360 $Y=199795
X2038 VSS: 2 VSS: 563 361 185 2 NAND2X4 $T=48760 204240 1 0 $X=48580 $Y=199795
X2042 VSS: 2 VSS: 193 347 190 2 NAND2X4_HS $T=39100 204240 1 180 $X=33860 $Y=203975
X2045 VSS: 2 VSS: 362 185 155 210 141 2 AOI22X2_HS $T=46920 204240 1 180 $X=41220 $Y=203975
X2050 VSS: 2 VSS: 363 156 146 2 NAND2X1 $T=38640 212520 1 0 $X=38460 $Y=208075
X2054 VSS: 2 VSS: 574 363 354 362 2 NAND3X4_HS $T=45540 212520 1 0 $X=45360 $Y=208075
X2059 VSS: 2 VSS: 364 155 206 2 NAND2X1 $T=38180 212520 0 0 $X=38000 $Y=212255
X2062 VSS: 2 VSS: 354 204 206 2 NAND2X1 $T=44620 212520 1 180 $X=42600 $Y=212255
X2065 VSS: 2 VSS: 578 359 364 363 563 2 AND4X2_HS $T=48760 212520 0 0 $X=48580 $Y=212255
X2066 VSS: 2 VSS: 197 361 270 2 NAND2X2 $T=35420 220800 0 180 $X=32940 $Y=216355
X2067 VSS: 2 VSS: 365 361 206 2 NAND2X2 $T=35420 220800 1 0 $X=35240 $Y=216355
X2069 VSS: 2 VSS: 366 321 190 2 NAND2X1 $T=43240 220800 0 180 $X=41220 $Y=216355
X2072 VSS: 2 VSS: 359 204 270 2 NAND2X2 $T=47380 220800 1 0 $X=47200 $Y=216355
X2078 VSS: 2 VSS: 369 365 182 2 NAND2X2_HS $T=37720 220800 1 180 $X=34320 $Y=220535
X2081 VSS: 2 VSS: 367 368 366 2 CLKAND2X2 $T=40020 220800 0 0 $X=39840 $Y=220535
X2084 VSS: 2 VSS: 368 210 146 2 NAND2X1 $T=45540 220800 1 180 $X=43520 $Y=220535
X2086 VSS: 2 VSS: 582 583 367 364 2 NAND3X4_HS $T=54280 220800 1 180 $X=47200 $Y=220535
X2087 VSS: 2 VSS: 371 369 198 2 NOR2X4_HS $T=38180 229080 0 180 $X=32940 $Y=224635
X2089 VSS: 2 VSS: 210 370 2 BUFX16_HS $T=49220 229080 0 180 $X=38920 $Y=224635
X2097 VSS: 2 VSS: 374 146 206 372 211 2 AOI22X1_HS $T=46460 229080 0 0 $X=46280 $Y=228815
X2100 VSS: 2 VSS: 376 372 141 2 NAND2X2 $T=43700 237360 0 180 $X=41220 $Y=232915
X2108 VSS: 2 VSS: 378 377 376 7 2 NAND3X4_HS $T=39100 237360 0 0 $X=38920 $Y=237095
X2110 VSS: 2 VSS: 379 380 8 201 208 2 NAND4X4_HS $T=42320 245640 0 180 $X=33400 $Y=241195
X2111 VSS: 2 VSS: 8 321 185 2 NAND2X1 $T=42320 245640 1 0 $X=42140 $Y=241195
X2116 VSS: 2 VSS: 208 155 146 2 NAND2X2 $T=35880 245640 1 180 $X=33400 $Y=245375
X2117 VSS: 2 VSS: 380 210 270 2 NAND2X2_HS $T=35880 245640 0 0 $X=35700 $Y=245375
X2120 VSS: 2 VSS: 6 372 206 2 NAND2X2_HS $T=45080 245640 1 180 $X=41680 $Y=245375
X2123 VSS: 2 VSS: 575 381 382 2 NAND2X4_HS $T=47380 245640 0 0 $X=47200 $Y=245375
X2128 VSS: 2 VSS: 211 384 2 BUFX8 $T=42320 253920 0 180 $X=37080 $Y=249475
X2136 VSS: 2 VSS: 382 270 185 384 372 2 AOI22X2_HS $T=47840 253920 1 180 $X=42140 $Y=253655
X2138 VSS: 2 VSS: 386 377 380 373 216 2 NAND4X1_HS $T=34960 262200 1 0 $X=34780 $Y=257755
X2142 VSS: 2 VSS: 5 385 270 2 NAND2X2 $T=43700 262200 0 180 $X=41220 $Y=257755
X2144 VSS: 2 VSS: 381 321 385 206 146 2 AOI22X2 $T=45540 262200 1 0 $X=45360 $Y=257755
X2150 VSS: 2 VSS: 377 385 206 2 NAND2X2 $T=43700 262200 1 180 $X=41220 $Y=261935
X2152 VSS: 2 VSS: 318 385 2 CLKBUFX4 $T=47380 262200 1 180 $X=44440 $Y=261935
X2156 VSS: 2 VSS: 216 321 146 2 NAND2X2 $T=38640 270480 0 180 $X=36160 $Y=266035
X2160 VSS: 2 VSS: 606 604 387 2 NOR2X4_HS $T=52900 270480 0 180 $X=47660 $Y=266035
X2164 VSS: 2 VSS: 388 217 389 2 NAND2X2_HS $T=33120 270480 0 0 $X=32940 $Y=270215
X2168 VSS: 2 VSS: 604 388 607 602 608 2 NAND4X2_HS $T=47380 270480 0 0 $X=47200 $Y=270215
X2170 VSS: 2 VSS: 387 391 390 2 NAND2X2_HS $T=42320 278760 0 180 $X=38920 $Y=274315
X2173 VSS: 2 VSS: 392 528 2 INVX4_HS $T=51060 278760 0 180 $X=47660 $Y=274315
X2180 VSS: 2 VSS: 391 394 393 286 218 2 AOI22X1_HS $T=39100 278760 0 0 $X=38920 $Y=278495
X2184 VSS: 2 VSS: 398 173 2 INVX2_HS $T=34500 287040 1 0 $X=34320 $Y=282595
X2189 VSS: 2 VSS: 397 386 378 389 396 2 AOI22X2_HS $T=45540 287040 1 0 $X=45360 $Y=282595
X2196 VSS: 2 VSS: 400 389 203 2 NAND2X2 $T=36800 287040 0 0 $X=36620 $Y=286775
X2199 VSS: 2 VSS: 395 399 2 INVX4 $T=48760 287040 1 180 $X=46280 $Y=286775
X2202 VSS: 2 VSS: 401 203 394 393 398 2 AOI22X2_HS $T=44620 295320 0 180 $X=38920 $Y=290875
X2209 VSS: 2 VSS: 402 217 2 INVX2 $T=34040 295320 0 0 $X=33860 $Y=295055
X2214 VSS: 2 VSS: 403 399 397 402 401 2 OAI211X2_HS $T=50600 295320 1 180 $X=44900 $Y=295055
X2219 VSS: 2 VSS: 167 404 2 CLKBUFX4 $T=45080 303600 0 180 $X=42140 $Y=299155
X2228 VSS: 2 VSS: 406 407 408 2 NAND2X2_HS $T=39100 311880 0 180 $X=35700 $Y=307435
X2231 VSS: 2 VSS: 407 410 addr_i[7] 2 NAND2X1 $T=41400 311880 1 0 $X=41220 $Y=307435
X2234 VSS: 2 VSS: 411 316 2 BUFX2 $T=45540 311880 1 0 $X=45360 $Y=307435
X2243 VSS: 2 VSS: 416 410 415 addr_i[11] 12 2 AOI22X2_HS $T=42320 320160 0 180 $X=36620 $Y=315715
X2245 VSS: 2 VSS: 417 316 370 2 NAND2X4_HS $T=44160 320160 1 0 $X=43980 $Y=315715
X2251 VSS: 2 VSS: 155 419 2 BUFX4_HS $T=46000 320160 1 180 $X=42140 $Y=319895
X2255 VSS: 2 VSS: 418 423 2 INVX2_HS $T=34960 328440 1 0 $X=34780 $Y=323995
X2257 VSS: 2 VSS: 423 addr_i[8] 415 410 255 2 AOI22X2_HS $T=43240 328440 0 180 $X=37540 $Y=323995
X2260 VSS: 2 VSS: 424 rst_i 2 CLKBUFX4 $T=46000 328440 1 0 $X=45820 $Y=323995
X2268 VSS: 2 VSS: 156 426 2 BUFX4_HS $T=43240 328440 1 180 $X=39380 $Y=328175
X2271 VSS: 2 VSS: 428 halt_cpu_i 424 427 2 AOI21X1 $T=45540 328440 0 0 $X=45360 $Y=328175
X2275 VSS: 2 VSS: 430 429 221 2 NAND2X2_HS $T=39100 336720 1 0 $X=38920 $Y=332275
X2284 VSS: 2 VSS: 429 431 2 INVX2 $T=39100 336720 0 0 $X=38920 $Y=336455
X2289 VSS: 2 VSS: 637 430 432 2 NAND2X4_HS $T=47380 336720 0 0 $X=47200 $Y=336455
X2291 VSS: 2 VSS: 435 33 434 2 AND2X1 $T=41860 345000 1 0 $X=41680 $Y=340555
X2293 VSS: 2 VSS: 432 450 223 435 2 AOI21X2 $T=51520 345000 0 180 $X=47660 $Y=340555
X2299 VSS: 2 VSS: 434 438 439 2 XNOR2X1 $T=42780 345000 1 180 $X=38920 $Y=344735
X2302 VSS: 2 VSS: 438 437 440 436 2 OAI21X1 $T=47380 345000 1 180 $X=44900 $Y=344735
X2304 VSS: 2 VSS: 640 437 2 INVX1 $T=48300 345000 0 0 $X=48120 $Y=344735
X2305 VSS: 2 VSS: 408 415 248 2 NAND2X2_HS $T=38640 353280 0 180 $X=35240 $Y=348835
X2307 VSS: 2 VSS: 439 444 443 2 NAND2X1 $T=42320 353280 0 180 $X=40300 $Y=348835
X2310 VSS: 2 VSS: 443 442 2 INVX1 $T=45080 353280 0 180 $X=43520 $Y=348835
X2311 VSS: 2 VSS: 441 437 442 2 NOR2X1_HS $T=45080 353280 1 0 $X=44900 $Y=348835
X2314 VSS: 2 VSS: 437 649 445 2 NOR2X1_HS $T=51060 353280 0 180 $X=48580 $Y=348835
X2320 VSS: 2 VSS: 236 447 446 441 2 AOI21X2_HS $T=37720 353280 0 0 $X=37540 $Y=353015
X2322 VSS: 2 VSS: 447 442 444 440 2 OAI21X1_HS $T=46920 353280 1 180 $X=43980 $Y=353015
X2328 VSS: 2 VSS: 444 233 449 2 NAND2X1 $T=43700 361560 0 180 $X=41680 $Y=357115
X2330 VSS: 2 VSS: 442 449 233 2 NOR2X1 $T=44160 361560 1 0 $X=43980 $Y=357115
X2333 VSS: 2 VSS: 347 448 2 CLKBUFX4 $T=50140 361560 0 180 $X=47200 $Y=357115
X2338 VSS: 2 VSS: 453 451 433 2 AND2X1 $T=38640 361560 1 180 $X=36160 $Y=361295
X2343 VSS: 2 VSS: 450 233 452 222 2 NOR3X1_HS $T=45540 361560 0 0 $X=45360 $Y=361295
X2347 VSS: 2 VSS: 233 431 455 454 2 DFFX1_HS $T=35420 369840 1 0 $X=35240 $Y=365395
X2349 VSS: 2 VSS: 455 451 637 2 AND2X1 $T=50600 369840 0 180 $X=48120 $Y=365395
X2355 VSS: 2 VSS: 231 228 453 454 2 DFFX1_HS $T=34040 369840 0 0 $X=33860 $Y=369575
X2358 VSS: 2 VSS: 222 457 445 456 2 NAND3X1 $T=47380 369840 0 0 $X=47200 $Y=369575
X2360 VSS: 2 VSS: 458 451 248 2 AND2X1 $T=36800 378120 1 0 $X=36620 $Y=373675
X2364 VSS: 2 VSS: 459 445 457 2 OR2X1 $T=47840 378120 0 180 $X=45360 $Y=373675
X2369 VSS: 2 VSS: 251 244 458 454 2 DFFX1_HS $T=33580 378120 0 0 $X=33400 $Y=377855
X2373 VSS: 2 VSS: 461 460 459 2 AND2X1 $T=46000 378120 0 0 $X=45820 $Y=377855
X2376 VSS: 2 VSS: 254 250 462 454 2 DFFX1_HS $T=33580 386400 1 0 $X=33400 $Y=381955
X2377 VSS: 2 VSS: 462 451 255 2 AND2X1 $T=42780 386400 1 0 $X=42600 $Y=381955
X2379 VSS: 2 VSS: 463 451 464 2 AND2X1 $T=51060 386400 0 180 $X=48580 $Y=381955
X2385 VSS: 2 VSS: 467 451 12 2 AND2X1 $T=40940 386400 1 180 $X=38460 $Y=386135
X2388 VSS: 2 VSS: 464 465 466 2 NAND2X4_HS $T=45080 386400 0 0 $X=44900 $Y=386135
X2390 VSS: 2 VSS: 468 14 467 454 2 DFFX1_HS $T=34500 394680 1 0 $X=34320 $Y=390235
X2391 VSS: 2 VSS: 24 664 463 454 2 DFFX1_HS $T=43700 394680 1 0 $X=43520 $Y=390235
X2396 VSS: 2 VSS: 16 223 2 INVX1_HS $T=38640 394680 1 180 $X=36620 $Y=394415
X2399 VSS: 2 VSS: 15 452 2 CLKBUFX2_HS $T=44620 394680 1 180 $X=41220 $Y=394415
X2401 VSS: 2 VSS: 469 24 452 470 2 NOR3X1_HS $T=51060 394680 1 180 $X=48120 $Y=394415
X2406 VSS: 2 VSS: 466 469 223 671 2 AOI21X2_HS $T=48760 402960 1 0 $X=48580 $Y=398515
X2410 VSS: 2 VSS: 470 265 243 2 NAND2X1 $T=33120 402960 0 0 $X=32940 $Y=402695
X2414 VSS: 2 VSS: 18 468 471 2 CLKXOR2X1 $T=46000 402960 1 180 $X=42600 $Y=402695
X2417 VSS: 2 VSS: 475 472 254 2 NOR2X1 $T=34040 411240 1 0 $X=33860 $Y=406795
X2420 VSS: 2 VSS: 476 254 472 2 NAND2X1 $T=38180 411240 1 0 $X=38000 $Y=406795
X2423 VSS: 2 VSS: 13 473 2 INVX1 $T=45540 411240 0 180 $X=43980 $Y=406795
X2425 VSS: 2 VSS: 671 33 474 2 AND2X1 $T=49220 411240 1 0 $X=49040 $Y=406795
X2429 VSS: 2 VSS: 477 475 2 INVX1 $T=35420 411240 1 180 $X=33860 $Y=410975
X2432 VSS: 2 VSS: 479 475 476 267 2 OAI21X2_HS $T=36800 411240 0 0 $X=36620 $Y=410975
X2435 VSS: 2 VSS: 473 478 33 2 CLKAND2X2 $T=44160 411240 0 0 $X=43980 $Y=410975
X2438 VSS: 2 VSS: 474 681 682 2 XNOR2X1 $T=52440 411240 1 180 $X=48580 $Y=410975
X2442 VSS: 2 VSS: 481 480 2 CLKINVX1 $T=42320 419520 0 180 $X=40760 $Y=415075
X2447 VSS: 2 VSS: 681 479 2 BUFX2 $T=49220 419520 1 0 $X=49040 $Y=415075
X2454 VSS: 2 VSS: 483 468 481 2 NAND2X1 $T=40480 419520 1 180 $X=38460 $Y=419255
X2458 VSS: 2 VSS: 478 482 688 687 2 OAI21X1_HS $T=48760 419520 0 0 $X=48580 $Y=419255
X2461 VSS: 2 VSS: 482 483 484 2 NAND2X1 $T=40020 427800 1 0 $X=39840 $Y=423355
X2466 VSS: 2 VSS: 688 482 687 2 NAND2X1_HS $T=48760 427800 1 0 $X=48580 $Y=423355
X2472 VSS: 2 VSS: 484 481 468 2 OR2X1 $T=39560 427800 0 0 $X=39380 $Y=427535
X2800 VSS: 2 VSS: 280 485 276 2 NAND2X2_HS $T=58880 30360 1 180 $X=55480 $Y=30095
X2807 VSS: 2 VSS: 487 486 271 2 NAND2X1_HS $T=54280 38640 1 0 $X=54100 $Y=34195
X2812 VSS: 2 VSS: 490 488 489 487 280 2 NAND4X2_HS $T=59800 38640 1 180 $X=54100 $Y=38375
X2813 VSS: 2 VSS: 491 490 2 BUFX8_HS $T=59800 38640 0 0 $X=59620 $Y=38375
X2821 VSS: 2 VSS: 492 274 140 148 485 2 OAI22X1 $T=55660 46920 1 0 $X=55480 $Y=42475
X2824 VSS: 2 VSS: 714 485 140 148 486 2 OAI22X1 $T=63940 46920 1 0 $X=63760 $Y=42475
X2826 VSS: 2 VSS: 489 493 141 2 NAND2X4_HS $T=52900 46920 0 0 $X=52720 $Y=46655
X2835 VSS: 2 VSS: 494 493 145 317 486 2 OAI22X1 $T=58420 55200 0 180 $X=55480 $Y=50755
X2838 VSS: 2 VSS: 495 486 140 148 493 2 OAI22X1 $T=61180 55200 1 0 $X=61000 $Y=50755
X2843 VSS: 2 VSS: 497 494 159 492 2 OAI21X1_HS $T=55660 55200 0 0 $X=55480 $Y=54935
X2846 VSS: 2 VSS: 498 493 317 145 496 2 OAI22X1 $T=62560 55200 0 0 $X=62380 $Y=54935
X2855 VSS: 2 VSS: 502 499 501 282 500 2 OAI211X1 $T=58880 63480 1 0 $X=58700 $Y=59035
X2859 VSS: 2 VSS: 500 726 159 495 2 OAI21X1 $T=67160 63480 0 180 $X=64680 $Y=59035
X2862 VSS: 2 VSS: 503 290 499 501 497 2 OAI211X2_HS $T=59340 63480 1 180 $X=53640 $Y=63215
X2866 VSS: 2 VSS: 504 499 2 CLKINVX2 $T=64400 63480 0 0 $X=64220 $Y=63215
X2872 VSS: 2 VSS: 501 506 2 BUFX2_HS $T=54280 71760 1 0 $X=54100 $Y=67315
X2875 VSS: 2 VSS: 505 504 506 2 NOR2X4_HS $T=63480 71760 0 180 $X=58240 $Y=67315
X2880 VSS: 2 VSS: 293 509 2 BUFX8 $T=52900 71760 0 0 $X=52720 $Y=71495
X2882 VSS: 2 VSS: 508 504 510 2 NOR2X4 $T=65780 71760 1 180 $X=61460 $Y=71495
X2889 VSS: 2 VSS: 511 510 2 BUFX2 $T=61640 80040 1 0 $X=61460 $Y=75595
X2892 VSS: 2 VSS: 142 295 293 2 NOR2X4_HS $T=51060 80040 0 0 $X=50880 $Y=79775
X2900 VSS: 2 VSS: 514 293 2 CLKINVX2 $T=55200 88320 1 0 $X=55020 $Y=83875
X2903 VSS: 2 VSS: 513 510 2 CLKBUFX2 $T=63940 88320 1 0 $X=63760 $Y=83875
X2907 VSS: 2 VSS: 510 514 515 2 NAND2X2 $T=59340 88320 0 0 $X=59160 $Y=88055
X2916 VSS: 2 VSS: 506 514 516 2 NAND2X2 $T=60260 96600 0 180 $X=57780 $Y=92155
X2922 VSS: 2 VSS: 309 520 2 BUFX2_HS $T=57960 96600 1 180 $X=55020 $Y=96335
X2925 VSS: 2 VSS: 521 514 2 CLKINVX2 $T=62560 96600 0 0 $X=62380 $Y=96335
X2931 VSS: 2 VSS: 523 309 271 2 NAND2X4_HS $T=50600 104880 1 0 $X=50420 $Y=100435
X2935 VSS: 2 VSS: 524 522 502 2 NOR2X2_HS $T=58880 104880 1 0 $X=58700 $Y=100435
X2939 VSS: 2 VSS: 525 396 505 282 308 2 AOI22X1_HS $T=58420 104880 1 180 $X=55020 $Y=104615
X2947 VSS: 2 VSS: 530 316 2 CLKINVX2 $T=54280 113160 1 0 $X=54100 $Y=108715
X2949 VSS: 2 VSS: 531 530 2 CLKINVX2 $T=59340 113160 1 0 $X=59160 $Y=108715
X2952 VSS: 2 VSS: 527 524 529 2 NAND2X2_HS $T=63020 113160 1 0 $X=62840 $Y=108715
X2955 VSS: 2 VSS: 532 523 323 300 294 2 NAND4X2_HS $T=53360 113160 0 0 $X=53180 $Y=112895
X2963 VSS: 2 VSS: 533 532 2 CLKINVX2_HS $T=54280 121440 1 0 $X=54100 $Y=116995
X2968 VSS: 2 VSS: 535 324 523 319 517 2 NAND4X2_HS $T=51520 121440 0 0 $X=51340 $Y=121175
X2970 VSS: 2 VSS: 534 396 2 BUFX2 $T=57960 121440 0 0 $X=57780 $Y=121175
X2974 VSS: 2 VSS: 750 499 521 2 NAND2X1 $T=65320 121440 0 0 $X=65140 $Y=121175
X2981 VSS: 2 VSS: 536 491 2 INVX4 $T=57960 129720 1 0 $X=57780 $Y=125275
X2986 VSS: 2 VSS: 147 302 303 2 NAND2X4_HS $T=57500 129720 1 180 $X=52260 $Y=129455
X2994 VSS: 2 VSS: 539 323 327 338 540 2 NAND4X2_HS $T=56120 138000 0 180 $X=50420 $Y=133555
X2998 VSS: 2 VSS: 396 754 2 BUFX8_HS $T=68080 138000 0 180 $X=62380 $Y=133555
X3001 VSS: 2 VSS: 543 324 327 2 CLKAND2X2 $T=50600 138000 0 0 $X=50420 $Y=137735
X3003 VSS: 2 VSS: 542 518 329 2 AND2X1_HS $T=53360 138000 0 0 $X=53180 $Y=137735
X3005 VSS: 2 VSS: 541 542 543 2 NAND2X2_HS $T=56580 138000 0 0 $X=56400 $Y=137735
X3006 VSS: 2 VSS: 73 541 2 INVX4_HS $T=59800 138000 0 0 $X=59620 $Y=137735
X3014 VSS: 2 VSS: 545 332 516 63 544 2 AOI22X2_HS $T=61180 146280 0 180 $X=55480 $Y=141835
X3019 VSS: 2 VSS: 540 170 141 2 NAND2X1 $T=51060 146280 0 0 $X=50880 $Y=146015
X3021 VSS: 2 VSS: 526 331 2 BUFX2_HS $T=53360 146280 0 0 $X=53180 $Y=146015
X3024 VSS: 2 VSS: 546 545 2 CLKBUFX2_HS $T=58420 146280 0 0 $X=58240 $Y=146015
X3026 VSS: 2 VSS: 761 759 760 297 537 2 NAND4X1_HS $T=65320 146280 0 0 $X=65140 $Y=146015
X3030 VSS: 2 VSS: 550 337 335 540 2 NAND3X2_HS $T=49680 154560 1 0 $X=49500 $Y=150115
X3031 VSS: 2 VSS: 548 550 2 INVX4_HS $T=54280 154560 1 0 $X=54100 $Y=150115
X3033 VSS: 2 VSS: 547 549 546 2 NAND2X4_HS $T=58420 154560 1 0 $X=58240 $Y=150115
X3037 VSS: 2 VSS: 552 553 2 INVX2_HS $T=54740 154560 0 0 $X=54560 $Y=154295
X3049 VSS: 2 VSS: 765 348 526 712 505 2 AOI22X1_HS $T=63940 162840 1 0 $X=63760 $Y=158395
X3052 VSS: 2 VSS: 553 525 554 383 2 NAND3X1_HS $T=51980 162840 0 0 $X=51800 $Y=162575
X3057 VSS: 2 VSS: 554 526 508 566 348 2 AOI22X1 $T=64860 162840 0 0 $X=64680 $Y=162575
X3063 VSS: 2 VSS: 555 345 2 INVX4_HS $T=51060 171120 1 0 $X=50880 $Y=166675
X3068 VSS: 2 VSS: 551 200 556 508 286 2 AOI22X1 $T=65780 171120 0 180 $X=62840 $Y=166675
X3073 VSS: 2 VSS: 557 348 508 505 379 2 AOI22X1 $T=61180 171120 0 0 $X=61000 $Y=170855
X3079 VSS: 2 VSS: 346 181 339 2 NAND2X2_HS $T=51060 179400 1 0 $X=50880 $Y=174955
X3082 VSS: 2 VSS: 558 526 2 CLKINVX1 $T=61640 179400 1 0 $X=61460 $Y=174955
X3088 VSS: 2 VSS: 560 348 516 63 200 2 AOI22X2_HS $T=62560 179400 1 180 $X=56860 $Y=179135
X3096 VSS: 2 VSS: 561 560 562 2 NAND2X2_HS $T=58420 187680 1 0 $X=58240 $Y=183235
X3101 VSS: 2 VSS: 568 142 2 CLKBUFX2 $T=54280 187680 0 0 $X=54100 $Y=187415
X3105 VSS: 2 VSS: 564 566 565 200 567 2 AOI22X1 $T=65320 187680 1 180 $X=62380 $Y=187415
X3110 VSS: 2 VSS: 351 191 141 2 NAND2X2 $T=52440 195960 0 180 $X=49960 $Y=191515
X3113 VSS: 2 VSS: 569 571 568 570 2 AOI21X2_HS $T=59800 195960 0 180 $X=55020 $Y=191515
X3117 VSS: 2 VSS: 571 558 564 588 557 2 OAI211X1_HS $T=68080 195960 0 180 $X=64680 $Y=191515
X3119 VSS: 2 VSS: 358 572 303 2 NOR2X2_HS $T=50600 195960 0 0 $X=50420 $Y=195695
X3121 VSS: 2 VSS: 572 302 2 INVX4_HS $T=57960 195960 1 180 $X=54560 $Y=195695
X3130 VSS: 2 VSS: 562 379 515 573 378 2 AOI22X1 $T=55660 204240 1 0 $X=55480 $Y=199795
X3134 VSS: 2 VSS: 567 378 2 BUFX2 $T=61640 204240 1 0 $X=61460 $Y=199795
X3139 VSS: 2 VSS: 549 574 515 573 575 2 AOI22X1_HS $T=55660 204240 0 0 $X=55480 $Y=203975
X3148 VSS: 2 VSS: 576 addr_i[11] 2 INVX1 $T=58880 212520 1 0 $X=58700 $Y=208075
X3154 VSS: 2 VSS: 326 577 2 BUFX8 $T=61180 212520 1 180 $X=55940 $Y=212255
X3164 VSS: 2 VSS: 580 579 200 2 NAND2X2 $T=57040 220800 0 180 $X=54560 $Y=216355
X3167 VSS: 2 VSS: 63 579 2 CLKBUFX4 $T=61640 220800 1 0 $X=61460 $Y=216355
X3171 VSS: 2 VSS: 581 582 2 INVX8_HS $T=60720 220800 1 180 $X=55480 $Y=220535
X3178 VSS: 2 VSS: 583 585 185 2 NAND2X1 $T=51060 229080 1 0 $X=50880 $Y=224635
X3182 VSS: 2 VSS: 584 586 2 INVX1_HS $T=56120 229080 1 0 $X=55940 $Y=224635
X3188 VSS: 2 VSS: 587 374 2 CLKBUFX4 $T=51060 229080 0 0 $X=50880 $Y=228815
X3191 VSS: 2 VSS: 589 573 378 2 NAND2X1 $T=58420 229080 1 180 $X=56400 $Y=228815
X3195 VSS: 2 VSS: 588 396 2 CLKINVX2 $T=63480 229080 0 0 $X=63300 $Y=228815
X3202 VSS: 2 VSS: 586 580 589 590 2 NAND3X2_HS $T=58420 237360 0 180 $X=53640 $Y=232915
X3205 VSS: 2 VSS: 591 579 2 BUFX4 $T=62560 237360 1 0 $X=62380 $Y=232915
X3207 VSS: 2 VSS: 7 211 146 2 NAND2X2 $T=49680 237360 0 0 $X=49500 $Y=237095
X3210 VSS: 2 VSS: 590 516 379 2 NAND2X1 $T=57960 237360 1 180 $X=55940 $Y=237095
X3213 VSS: 2 VSS: 592 379 516 597 378 2 AOI22X2_HS $T=69000 237360 1 180 $X=63300 $Y=237095
X3219 VSS: 2 VSS: 390 593 586 2 NAND2X2_HS $T=55660 245640 0 180 $X=52260 $Y=241195
X3222 VSS: 2 VSS: 594 591 375 2 NAND2X2_HS $T=63020 245640 1 0 $X=62840 $Y=241195
X3225 VSS: 2 VSS: 596 515 2 CLKINVX1 $T=56580 245640 1 180 $X=55020 $Y=245375
X3227 VSS: 2 VSS: 595 6 596 2 OR2X1_HS $T=58420 245640 0 0 $X=58240 $Y=245375
X3230 VSS: 2 VSS: 789 595 599 2 CLKAND2X2 $T=65320 245640 0 0 $X=65140 $Y=245375
X3236 VSS: 2 VSS: 383 598 389 393 491 2 AOI22X1_HS $T=55660 253920 0 180 $X=52260 $Y=249475
X3240 VSS: 2 VSS: 579 597 2 CLKBUFX2_HS $T=65320 253920 0 180 $X=61920 $Y=249475
X3244 VSS: 2 VSS: 598 600 2 CLKINVX1 $T=57040 253920 1 180 $X=55480 $Y=253655
X3249 VSS: 2 VSS: 599 778 214 2 NAND2X2 $T=66240 253920 1 180 $X=63760 $Y=253655
X3257 VSS: 2 VSS: 602 598 601 2 NAND2X2_HS $T=55200 262200 1 0 $X=55020 $Y=257755
X3260 VSS: 2 VSS: 585 385 2 CLKBUFX2 $T=50140 262200 0 0 $X=49960 $Y=261935
X3264 VSS: 2 VSS: 603 298 2 CLKINVX2_HS $T=61180 262200 1 180 $X=57320 $Y=261935
X3273 VSS: 2 VSS: 605 573 491 2 NAND2X2 $T=62100 270480 1 0 $X=61920 $Y=266035
X3278 VSS: 2 VSS: 609 330 394 2 NAND2X2_HS $T=65320 270480 1 180 $X=61920 $Y=270215
X3284 VSS: 2 VSS: 611 286 579 516 392 2 AOI22X2_HS $T=57500 278760 0 180 $X=51800 $Y=274315
X3286 VSS: 2 VSS: 610 612 605 600 611 2 OAI211X2_HS $T=64860 278760 0 180 $X=59160 $Y=274315
X3288 VSS: 2 VSS: 608 392 395 2 NAND2X2 $T=49680 278760 0 0 $X=49500 $Y=278495
X3292 VSS: 2 VSS: 570 610 2 BUFX2 $T=59340 278760 1 180 $X=56860 $Y=278495
X3294 VSS: 2 VSS: 613 603 610 2 NAND2X2_HS $T=64400 278760 1 180 $X=61000 $Y=278495
X3306 VSS: 2 VSS: 616 399 400 219 614 2 OAI211X2_HS $T=61180 287040 1 180 $X=55480 $Y=286775
X3307 VSS: 2 VSS: 617 613 615 2 NAND2X4_HS $T=61180 287040 0 0 $X=61000 $Y=286775
X3314 VSS: 2 VSS: 614 217 601 393 491 2 AOI22X2_HS $T=55200 295320 1 0 $X=55020 $Y=290875
X3320 VSS: 2 VSS: 615 403 618 2 NOR2X4_HS $T=64860 295320 1 180 $X=59620 $Y=295055
X3327 VSS: 2 VSS: 607 491 619 2 NAND2X2_HS $T=56120 303600 0 180 $X=52720 $Y=299155
X3335 VSS: 2 VSS: 618 620 2 INVX4_HS $T=58880 303600 0 0 $X=58700 $Y=303335
X3340 VSS: 2 VSS: 621 622 2 BUFX8_HS $T=49680 311880 1 0 $X=49500 $Y=307435
X3342 VSS: 2 VSS: 623 509 2 INVX8_HS $T=61180 311880 0 180 $X=55940 $Y=307435
X3347 VSS: 2 VSS: 622 499 411 2 NAND2X1 $T=52900 311880 1 180 $X=50880 $Y=311615
X3351 VSS: 2 VSS: 624 561 2 BUFX2 $T=58880 311880 0 0 $X=58700 $Y=311615
X3359 VSS: 2 VSS: 626 627 625 623 2 OAI21X2_HS $T=55200 320160 1 0 $X=55020 $Y=315715
X3362 VSS: 2 VSS: 826 628 634 626 2 OAI21X2_HS $T=63940 320160 1 0 $X=63760 $Y=315715
X3364 VSS: 2 VSS: 629 316 417 370 2 OAI21X2_HS $T=51520 320160 0 0 $X=51340 $Y=319895
X3368 VSS: 2 VSS: 628 635 2 INVX2_HS $T=66700 320160 1 180 $X=64220 $Y=319895
X3373 VSS: 2 VSS: 630 627 625 623 2 OAI21X2_HS $T=56120 328440 1 0 $X=55940 $Y=323995
X3377 VSS: 2 VSS: 631 427 428 en_cpu_i 2 OAI21X1 $T=50600 328440 0 0 $X=50420 $Y=328175
X3380 VSS: 2 VSS: 634 633 630 2 NAND2X2_HS $T=60260 328440 1 180 $X=56860 $Y=328175
X3383 VSS: 2 VSS: 633 635 2 INVX2_HS $T=67160 328440 1 180 $X=64680 $Y=328175
X3393 VSS: 2 VSS: 636 635 2 CLKINVX2 $T=65320 336720 0 180 $X=63760 $Y=332275
X3399 VSS: 2 VSS: 625 638 639 2 OR2X1 $T=61180 336720 1 180 $X=58700 $Y=336455
X3409 VSS: 2 VSS: 641 440 640 2 NAND2X1 $T=49680 345000 0 0 $X=49500 $Y=344735
X3412 VSS: 2 VSS: 643 641 33 436 2 OAI21X1 $T=52900 345000 0 0 $X=52720 $Y=344735
X3413 VSS: 2 VSS: 644 641 643 436 2 AOI21X1 $T=55200 345000 0 0 $X=55020 $Y=344735
X3415 VSS: 2 VSS: 646 644 223 2 NAND2X2_HS $T=59340 345000 0 0 $X=59160 $Y=344735
X3417 VSS: 2 VSS: 642 645 2 INVX1 $T=64400 345000 0 0 $X=64220 $Y=344735
X3422 VSS: 2 VSS: 649 638 2 INVX2 $T=53360 353280 0 180 $X=51800 $Y=348835
X3423 VSS: 2 VSS: 436 446 2 INVX1 $T=54740 353280 0 180 $X=53180 $Y=348835
X3426 VSS: 2 VSS: 446 32 647 645 2 OAI21X2_HS $T=61640 353280 0 180 $X=56860 $Y=348835
X3428 VSS: 2 VSS: 645 457 648 2 NOR2X2 $T=62100 353280 1 0 $X=61920 $Y=348835
X3429 VSS: 2 VSS: 647 457 648 2 NAND2X1 $T=64860 353280 1 0 $X=64680 $Y=348835
X3431 VSS: 2 VSS: 440 445 649 2 NAND2X2 $T=50140 353280 0 0 $X=49960 $Y=353015
X3434 VSS: 2 VSS: 651 650 2 BUFX2 $T=59340 353280 1 180 $X=56860 $Y=353015
X3442 VSS: 2 VSS: 650 654 652 653 646 2 OAI211X2_HS $T=59800 361560 0 180 $X=54100 $Y=357115
X3446 VSS: 2 VSS: 853 851 849 852 2 NAND3X4_HS $T=64860 361560 1 0 $X=64680 $Y=357115
X3447 VSS: 2 VSS: 655 456 452 2 NOR2X2_HS $T=51980 361560 0 0 $X=51800 $Y=361295
X3450 VSS: 2 VSS: 653 230 655 2 NOR2X2_HS $T=59800 361560 1 180 $X=56400 $Y=361295
X3453 VSS: 2 VSS: 656 655 2 CLKINVX1 $T=61180 361560 0 0 $X=61000 $Y=361295
X3461 VSS: 2 VSS: 659 451 651 2 AND2X1_HS $T=58420 369840 0 180 $X=55480 $Y=365395
X3464 VSS: 2 VSS: 658 451 657 2 AND2X1 $T=63480 369840 0 180 $X=61000 $Y=365395
X3469 VSS: 2 VSS: 445 654 659 454 2 DFFX1_HS $T=53820 369840 0 0 $X=53640 $Y=369575
X3474 VSS: 2 VSS: 460 445 457 660 2 OAI21X1 $T=53820 378120 0 180 $X=51340 $Y=373675
X3476 VSS: 2 VSS: 456 660 658 454 2 DFFX1_HS $T=57500 378120 1 0 $X=57320 $Y=373675
X3480 VSS: 2 VSS: 652 461 27 2 NAND2X4_HS $T=51520 378120 0 0 $X=51340 $Y=377855
X3483 VSS: 2 VSS: 457 856 661 454 2 DFFX1_HS $T=57960 378120 0 0 $X=57780 $Y=377855
X3488 VSS: 2 VSS: 27 452 2 INVX8_HS $T=54740 386400 1 0 $X=54560 $Y=381955
X3489 VSS: 2 VSS: 454 662 2 CLKBUFX4 $T=62560 386400 0 180 $X=59620 $Y=381955
X3491 VSS: 2 VSS: 665 664 2 INVX2 $T=50140 386400 0 0 $X=49960 $Y=386135
X3493 VSS: 2 VSS: 465 665 663 2 NAND2X2_HS $T=52440 386400 0 0 $X=52260 $Y=386135
X3496 VSS: 2 VSS: 663 666 2 INVX2_HS $T=57040 386400 0 0 $X=56860 $Y=386135
X3500 VSS: 2 VSS: 668 230 470 27 2 AOI21X2_HS $T=67160 386400 1 180 $X=62380 $Y=386135
X3506 VSS: 2 VSS: 666 230 470 27 2 AOI21X2_HS $T=54280 394680 1 0 $X=54100 $Y=390235
X3507 VSS: 2 VSS: 26 866 667 454 2 DFFX1_HS $T=58880 394680 1 0 $X=58700 $Y=390235
X3512 VSS: 2 VSS: 669 866 23 668 670 2 OAI211X2_HS $T=68080 394680 1 180 $X=62380 $Y=394415
X3519 VSS: 2 VSS: 25 26 24 470 2 OAI21X1 $T=60720 402960 0 180 $X=58240 $Y=398515
X3521 VSS: 2 VSS: 670 868 223 2 NAND2X4_HS $T=67620 402960 0 180 $X=62380 $Y=398515
X3525 VSS: 2 VSS: 471 24 672 26 2 NAND3X1 $T=54740 402960 0 0 $X=54560 $Y=402695
X3528 VSS: 2 VSS: 672 470 2 INVX1 $T=62560 402960 1 180 $X=61000 $Y=402695
X3534 VSS: 2 VSS: 675 24 673 2 NAND2X1 $T=53820 411240 0 180 $X=51800 $Y=406795
X3536 VSS: 2 VSS: 676 673 24 2 OR2X1 $T=54740 411240 1 0 $X=54560 $Y=406795
X3539 VSS: 2 VSS: 678 674 26 2 NOR2X1 $T=61180 411240 0 180 $X=59160 $Y=406795
X3541 VSS: 2 VSS: 677 26 674 2 NAND2X1 $T=62100 411240 1 0 $X=61920 $Y=406795
X3544 VSS: 2 VSS: 685 675 2 INVX1 $T=53360 411240 0 0 $X=53180 $Y=410975
X3545 VSS: 2 VSS: 682 675 676 2 NAND2X1 $T=54740 411240 0 0 $X=54560 $Y=410975
X3548 VSS: 2 VSS: 679 684 2 CLKBUFX2 $T=57960 411240 0 0 $X=57780 $Y=410975
X3551 VSS: 2 VSS: 683 680 33 679 2 OAI21X1 $T=61640 411240 0 0 $X=61460 $Y=410975
X3553 VSS: 2 VSS: 868 683 680 679 2 AOI21X2_HS $T=64400 411240 0 0 $X=64220 $Y=410975
X3558 VSS: 2 VSS: 684 685 479 676 2 AOI21X2_HS $T=53360 419520 1 0 $X=53180 $Y=415075
X3560 VSS: 2 VSS: 686 678 2 INVX1 $T=59800 419520 1 0 $X=59620 $Y=415075
X3561 VSS: 2 VSS: 680 677 686 2 NAND2X1 $T=61180 419520 1 0 $X=61000 $Y=415075
X3567 VSS: 2 VSS: 687 678 677 684 2 OAI21X2_HS $T=61180 419520 1 180 $X=56400 $Y=419255
X3571 VSS: 2 VSS: 883 689 693 2 NOR2X4_HS $T=64400 419520 0 0 $X=64220 $Y=419255
X3579 VSS: 2 VSS: 690 689 2 BUFX4_HS $T=64860 427800 0 180 $X=61000 $Y=423355
X3583 VSS: 2 VSS: 692 691 2 CLKINVX1 $T=54280 427800 0 0 $X=54100 $Y=427535
X3593 VSS: 2 VSS: 695 694 692 693 2 NAND3X1_HS $T=53360 436080 1 0 $X=53180 $Y=431635
X3598 VSS: 2 VSS: 886 691 890 889 883 2 NAND4X2_HS $T=70380 436080 0 180 $X=64680 $Y=431635
X3599 VSS: 2 VSS: 697 693 691 2 NOR2X2_HS $T=49680 436080 0 0 $X=49500 $Y=435815
X3603 VSS: 2 VSS: 696 695 699 698 2 NAND3X2_HS $T=63940 436080 1 180 $X=59160 $Y=435815
X3610 VSS: 2 VSS: 701 694 2 INVX2_HS $T=52900 444360 1 0 $X=52720 $Y=439915
X3613 VSS: 2 VSS: 700 701 697 2 NAND2X2_HS $T=57960 444360 1 0 $X=57780 $Y=439915
X3617 VSS: 2 VSS: 699 690 2 INVX1 $T=65780 444360 0 180 $X=64220 $Y=439915
X3620 VSS: 2 VSS: 698 697 701 2 NAND2X2_HS $T=52900 444360 0 0 $X=52720 $Y=444095
X3624 VSS: 2 VSS: 702 698 2 INVX1 $T=61180 444360 0 0 $X=61000 $Y=444095
X3752 VSS: 2 VSS: 943 935 941 942 934 2 AOI22X2_HS $T=64860 527160 1 0 $X=64680 $Y=522715
X3758 VSS: 2 VSS: 944 925 942 941 926 2 AOI22X2 $T=69920 527160 1 180 $X=65140 $Y=526895
X3781 VSS: 2 VSS: 949 704 948 706 705 2 AOI22X2 $T=62560 543720 1 0 $X=62380 $Y=539275
X3786 VSS: 2 VSS: 951 940 948 706 939 2 AOI22X2_HS $T=70380 543720 1 180 $X=64680 $Y=543455
X3800 VSS: 2 VSS: 955 944 954 949 707 2 NAND4X4_HS $T=72220 552000 1 180 $X=63300 $Y=551735
X3808 VSS: 2 VSS: 954 912 956 957 901 2 AOI22X2_HS $T=70380 560280 0 180 $X=64680 $Y=555835
X3836 VSS: 2 VSS: 963 708 962 2 NOR2X2_HS $T=64400 576840 1 0 $X=64220 $Y=572395
X3851 VSS: 2 VSS: 965 967 961 2 NOR2X2_HS $T=65320 585120 1 0 $X=65140 $Y=580675
X3964 VSS: 2 VSS: 709 272 276 2 NAND2X2 $T=80040 22080 0 0 $X=79860 $Y=21815
X3973 VSS: 2 VSS: 710 711 508 712 332 2 AOI22X1_HS $T=71300 30360 0 0 $X=71120 $Y=30095
X3979 VSS: 2 VSS: 713 711 332 505 712 2 AOI22X1 $T=72220 38640 1 0 $X=72040 $Y=34195
X3982 VSS: 2 VSS: 488 496 275 2 NAND2X2_HS $T=67160 38640 0 0 $X=66980 $Y=38375
X3987 VSS: 2 VSS: 979 980 713 2 NAND2X1_HS $T=84180 38640 1 180 $X=81700 $Y=38375
X3992 VSS: 2 VSS: 715 486 485 275 141 2 AOI22X2_HS $T=82340 46920 0 180 $X=76640 $Y=42475
X3997 VSS: 2 VSS: 716 715 281 283 2 NAND3X4_HS $T=82800 46920 1 180 $X=75720 $Y=46655
X3999 VSS: 2 VSS: 717 493 140 148 496 2 OAI22X1 $T=66240 55200 1 0 $X=66060 $Y=50755
X4003 VSS: 2 VSS: 718 716 2 INVX4_HS $T=80040 55200 1 0 $X=79860 $Y=50755
X4006 VSS: 2 VSS: 719 714 159 498 2 OAI21X1 $T=68540 55200 0 0 $X=68360 $Y=54935
X4008 VSS: 2 VSS: 723 721 159 717 2 OAI21X1 $T=74980 55200 1 180 $X=72500 $Y=54935
X4012 VSS: 2 VSS: 720 722 719 2 NAND2X2_HS $T=81420 55200 1 180 $X=78020 $Y=54935
X4017 VSS: 2 VSS: 728 499 501 725 723 2 OAI211X1 $T=72220 63480 1 0 $X=72040 $Y=59035
X4020 VSS: 2 VSS: 722 724 727 2 NOR2X1_HS $T=79120 63480 1 0 $X=78940 $Y=59035
X4025 VSS: 2 VSS: 727 499 2 INVX4_HS $T=69000 63480 0 0 $X=68820 $Y=63215
X4028 VSS: 2 VSS: 730 728 729 2 NOR2X1_HS $T=76820 63480 1 180 $X=74340 $Y=63215
X4031 VSS: 2 VSS: 983 291 141 2 NAND2X2 $T=80960 63480 0 0 $X=80780 $Y=63215
X4032 VSS: 2 VSS: 712 504 732 2 NOR2X4_HS $T=66240 71760 1 0 $X=66060 $Y=67315
X4035 VSS: 2 VSS: 729 732 711 731 511 2 OAI22X1 $T=79580 71760 0 180 $X=76640 $Y=67315
X4040 VSS: 2 VSS: 732 507 734 2 NAND2X2 $T=70840 71760 0 0 $X=70660 $Y=71495
X4043 VSS: 2 VSS: 733 531 730 547 2 OAI21X2_HS $T=83260 71760 1 180 $X=78480 $Y=71495
X4046 VSS: 2 VSS: 735 296 734 2 NAND2X2_HS $T=71760 80040 1 0 $X=71580 $Y=75595
X4051 VSS: 2 VSS: 734 736 2 INVX4_HS $T=74520 80040 1 180 $X=71120 $Y=79775
X4059 VSS: 2 VSS: 738 732 539 737 513 2 OAI22X1 $T=75900 88320 1 0 $X=75720 $Y=83875
X4062 VSS: 2 VSS: 399 735 2 BUFX8_HS $T=76360 88320 1 180 $X=70660 $Y=88055
X4067 VSS: 2 VSS: 517 301 276 2 NAND2X2 $T=72220 96600 0 180 $X=69740 $Y=92155
X4071 VSS: 2 VSS: 994 539 508 712 340 2 AOI22X1 $T=84180 96600 0 180 $X=81240 $Y=92155
X4074 VSS: 2 VSS: 741 503 740 2 NOR2X1_HS $T=72220 96600 1 180 $X=69740 $Y=96335
X4076 VSS: 2 VSS: 739 741 742 2 NAND2X2_HS $T=75900 96600 0 0 $X=75720 $Y=96335
X4080 VSS: 2 VSS: 522 732 526 308 511 2 OAI22X1 $T=69920 104880 0 180 $X=66980 $Y=100435
X4083 VSS: 2 VSS: 743 732 2 CLKINVX2 $T=77280 104880 1 0 $X=77100 $Y=100435
X4087 VSS: 2 VSS: 745 308 2 BUFX2 $T=69460 104880 1 180 $X=66980 $Y=104615
X4092 VSS: 2 VSS: 742 744 531 2 OR2X1_HS $T=79120 104880 1 180 $X=76180 $Y=104615
X4097 VSS: 2 VSS: 740 732 746 151 513 2 OAI22X1 $T=74980 113160 0 180 $X=72040 $Y=108715
X4101 VSS: 2 VSS: 529 561 531 2 OR2X1_HS $T=70840 113160 1 180 $X=67900 $Y=112895
X4104 VSS: 2 VSS: 748 513 2 CLKINVX2 $T=76360 113160 0 0 $X=76180 $Y=112895
X4107 VSS: 2 VSS: 749 745 534 2 AND2X1_HS $T=66240 121440 1 0 $X=66060 $Y=116995
X4111 VSS: 2 VSS: 747 360 2 INVX2_HS $T=76820 121440 1 0 $X=76640 $Y=116995
X4116 VSS: 2 VSS: 711 535 2 BUFX4_HS $T=74980 121440 0 0 $X=74800 $Y=121175
X4118 VSS: 2 VSS: 159 751 2 BUFX2 $T=69920 129720 0 180 $X=67440 $Y=125275
X4123 VSS: 2 VSS: 752 711 534 2 AND2X1 $T=78660 129720 1 0 $X=78480 $Y=125275
X4125 VSS: 2 VSS: 751 521 753 2 NOR2X2_HS $T=66700 129720 0 0 $X=66520 $Y=129455
X4130 VSS: 2 VSS: 754 751 499 2 CLKAND2X2 $T=68080 138000 1 0 $X=67900 $Y=133555
X4135 VSS: 2 VSS: 756 755 752 2 OR2X1_HS $T=79120 138000 1 0 $X=78940 $Y=133555
X4139 VSS: 2 VSS: 757 754 2 CLKBUFX2_HS $T=69460 138000 0 0 $X=69280 $Y=137735
X4145 VSS: 2 VSS: 758 332 544 505 712 2 AOI22X1 $T=73140 146280 1 0 $X=72960 $Y=141835
X4152 VSS: 2 VSS: 1016 758 71 762 763 2 OAI211X1 $T=80040 146280 0 0 $X=79860 $Y=146015
X4154 VSS: 2 VSS: 764 551 765 2 NAND2X2_HS $T=67620 154560 1 0 $X=67440 $Y=150115
X4162 VSS: 2 VSS: 766 189 174 712 505 2 AOI22X1 $T=75900 154560 0 0 $X=75720 $Y=154295
X4173 VSS: 2 VSS: 566 712 2 BUFX2_HS $T=79120 162840 1 180 $X=76180 $Y=162575
X4178 VSS: 2 VSS: 746 174 2 BUFX2 $T=77280 171120 0 180 $X=74800 $Y=166675
X4188 VSS: 2 VSS: 767 757 375 746 566 2 AOI22X1_HS $T=77740 179400 0 180 $X=74340 $Y=174955
X4189 VSS: 2 VSS: 768 767 2 CLKINVX1 $T=77740 179400 1 0 $X=77560 $Y=174955
X4191 VSS: 2 VSS: 565 750 753 2 NOR2X2_HS $T=65780 179400 0 0 $X=65600 $Y=179135
X4194 VSS: 2 VSS: 769 565 2 INVX2 $T=71760 179400 0 0 $X=71580 $Y=179135
X4199 VSS: 2 VSS: 770 142 2 INVX4_HS $T=70840 187680 1 0 $X=70660 $Y=183235
X4204 VSS: 2 VSS: 753 597 2 CLKINVX8 $T=74980 187680 1 180 $X=70660 $Y=187415
X4209 VSS: 2 VSS: 771 597 142 2 AND2X2_HS $T=73600 195960 1 0 $X=73420 $Y=191515
X4211 VSS: 2 VSS: 556 771 2 BUFX2 $T=80960 195960 0 180 $X=78480 $Y=191515
X4214 VSS: 2 VSS: 772 591 544 2 NAND2X2 $T=70380 195960 1 180 $X=67900 $Y=195695
X4218 VSS: 2 VSS: 70 771 2 INVX4 $T=81420 195960 0 0 $X=81240 $Y=195695
X4220 VSS: 2 VSS: 774 773 772 2 NAND2X1_HS $T=71760 204240 0 180 $X=69280 $Y=199795
X4223 VSS: 2 VSS: 775 750 2 BUFX2 $T=76360 204240 1 0 $X=76180 $Y=199795
X4228 VSS: 2 VSS: 776 774 778 575 2 AOI21X2_HS $T=69460 204240 0 0 $X=69280 $Y=203975
X4232 VSS: 2 VSS: 777 776 2 INVX2_HS $T=80500 204240 0 0 $X=80320 $Y=203975
X4235 VSS: 2 VSS: 780 63 360 2 NAND2X1_HS $T=67160 212520 1 0 $X=66980 $Y=208075
X4238 VSS: 2 VSS: 773 779 574 2 NAND2X2 $T=75900 212520 0 180 $X=73420 $Y=208075
X4241 VSS: 2 VSS: 1042 574 779 591 575 2 AOI22X2_HS $T=86020 212520 0 180 $X=80320 $Y=208075
X4243 VSS: 2 VSS: 781 736 780 587 2 OAI21X2_HS $T=74980 212520 1 180 $X=70200 $Y=212255
X4247 VSS: 2 VSS: 783 781 779 782 2 AOI21X2_HS $T=73600 220800 0 180 $X=68820 $Y=216355
X4251 VSS: 2 VSS: 779 998 2 CLKINVX4 $T=83720 220800 0 180 $X=81240 $Y=216355
X4252 VSS: 2 VSS: 782 581 2 CLKINVX2_HS $T=69460 220800 1 180 $X=65600 $Y=220535
X4255 VSS: 2 VSS: 389 771 2 CLKBUFX4 $T=76820 220800 1 180 $X=73880 $Y=220535
X4258 VSS: 2 VSS: 784 771 2 CLKINVX2 $T=79580 220800 0 0 $X=79400 $Y=220535
X4264 VSS: 2 VSS: 786 582 779 591 785 2 AOI22X2 $T=75900 229080 1 0 $X=75720 $Y=224635
X4266 VSS: 2 VSS: 787 375 591 779 189 2 AOI22X1_HS $T=68540 229080 0 0 $X=68360 $Y=228815
X4269 VSS: 2 VSS: 785 587 2 CLKINVX2 $T=76360 229080 0 0 $X=76180 $Y=228815
X4273 VSS: 2 VSS: 744 789 787 2 NAND2X4_HS $T=68080 237360 1 0 $X=67900 $Y=232915
X4277 VSS: 2 VSS: 788 591 785 593 2 NAND3X1_HS $T=83720 237360 0 180 $X=80780 $Y=232915
X4281 VSS: 2 VSS: 790 214 2 CLKINVX2 $T=77280 237360 0 0 $X=77100 $Y=237095
X4287 VSS: 2 VSS: 1052 791 591 779 214 2 AOI22X2_HS $T=80960 245640 1 0 $X=80780 $Y=241195
X4292 VSS: 2 VSS: 792 778 791 2 NAND2X2 $T=74520 245640 0 0 $X=74340 $Y=245375
X4296 VSS: 2 VSS: 793 792 594 2 NAND2X1_HS $T=72220 253920 0 180 $X=69740 $Y=249475
X4301 VSS: 2 VSS: 1054 793 779 214 2 AOI21X2_HS $T=81880 253920 1 0 $X=81700 $Y=249475
X4305 VSS: 2 VSS: 795 209 389 2 NAND2X2 $T=72220 253920 0 0 $X=72040 $Y=253655
X4308 VSS: 2 VSS: 192 794 2 BUFX8_HS $T=82800 253920 1 180 $X=77100 $Y=253655
X4312 VSS: 2 VSS: 593 621 2 CLKINVX2 $T=73140 262200 0 180 $X=71580 $Y=257755
X4315 VSS: 2 VSS: 798 797 796 2 NAND2X2_HS $T=80960 262200 0 180 $X=77560 $Y=257755
X4318 VSS: 2 VSS: 799 597 603 2 NAND2X4_HS $T=69460 262200 0 0 $X=69280 $Y=261935
X4323 VSS: 2 VSS: 736 1057 2 BUFX4_HS $T=85100 262200 1 180 $X=81240 $Y=261935
X4326 VSS: 2 VSS: 573 778 2 BUFX4_HS $T=70840 270480 1 0 $X=70660 $Y=266035
X4333 VSS: 2 VSS: 800 603 778 2 NAND2X2 $T=72220 270480 0 0 $X=72040 $Y=270215
X4339 VSS: 2 VSS: 612 515 2 CLKINVX1 $T=69460 278760 0 180 $X=67900 $Y=274315
X4343 VSS: 2 VSS: 801 603 516 2 NAND2X4_HS $T=75900 278760 1 0 $X=75720 $Y=274315
X4345 VSS: 2 VSS: 394 802 2 INVX4 $T=68540 278760 1 180 $X=66060 $Y=278495
X4348 VSS: 2 VSS: 803 800 600 528 802 2 OAI22X2_HS $T=73140 278760 0 0 $X=72960 $Y=278495
X4351 VSS: 2 VSS: 806 286 2 CLKBUFX2 $T=69460 287040 1 0 $X=69280 $Y=282595
X4354 VSS: 2 VSS: 804 528 2 CLKBUFX2 $T=75900 287040 1 0 $X=75720 $Y=282595
X4356 VSS: 2 VSS: 805 536 70 802 219 2 OAI22X1 $T=84640 287040 0 180 $X=81700 $Y=282595
X4359 VSS: 2 VSS: 809 803 619 806 616 2 AOI211X2_HS $T=70380 287040 0 0 $X=70200 $Y=286775
X4362 VSS: 2 VSS: 807 808 395 806 805 2 AOI211X2_HS $T=77280 287040 0 0 $X=77100 $Y=286775
X4365 VSS: 2 VSS: 810 621 809 592 812 2 OAI211X1_HS $T=75900 295320 0 180 $X=72500 $Y=290875
X4368 VSS: 2 VSS: 1070 813 811 2 AND2X1_HS $T=80040 295320 1 0 $X=79860 $Y=290875
X4370 VSS: 2 VSS: 812 815 814 2 NAND2X1_HS $T=69460 295320 0 0 $X=69280 $Y=295055
X4373 VSS: 2 VSS: 816 1070 2 BUFX16_HS $T=86480 295320 1 180 $X=76180 $Y=295055
X4376 VSS: 2 VSS: 817 819 818 2 NAND2X1 $T=73140 303600 0 180 $X=71120 $Y=299155
X4380 VSS: 2 VSS: 815 821 820 2 NOR2X2_HS $T=65780 303600 0 0 $X=65600 $Y=303335
X4384 VSS: 2 VSS: 819 822 2 CLKBUFX2 $T=77280 303600 1 180 $X=74800 $Y=303335
X4387 VSS: 2 VSS: 821 82 2 CLKINVX2 $T=83260 303600 1 180 $X=81700 $Y=303335
X4388 VSS: 2 VSS: 820 824 825 2 NOR2X2_HS $T=66700 311880 1 0 $X=66520 $Y=307435
X4392 VSS: 2 VSS: 818 823 2 INVX1 $T=79120 311880 0 180 $X=77560 $Y=307435
X4394 VSS: 2 VSS: 814 824 825 2 NAND2X1 $T=68540 311880 0 0 $X=68360 $Y=311615
X4398 VSS: 2 VSS: 823 1079 826 2 NOR2X4_HS $T=83260 311880 1 180 $X=78020 $Y=311615
X4402 VSS: 2 VSS: 822 827 826 2 NAND2X1_HS $T=74980 320160 1 0 $X=74800 $Y=315715
X4407 VSS: 2 VSS: 827 370 2 BUFX4_HS $T=70840 320160 0 0 $X=70660 $Y=319895
X4409 VSS: 2 VSS: 829 321 828 2 NOR2X2_HS $T=81420 320160 1 180 $X=78020 $Y=319895
X4411 VSS: 2 VSS: 831 635 2 INVX4 $T=68080 328440 1 0 $X=67900 $Y=323995
X4414 VSS: 2 VSS: 828 831 832 830 2 OAI21X2_HS $T=73140 328440 1 0 $X=72960 $Y=323995
X4416 VSS: 2 VSS: 1075 321 833 2 NAND2X2_HS $T=81420 328440 1 0 $X=81240 $Y=323995
X4419 VSS: 2 VSS: 833 831 832 830 2 OAI21X2_HS $T=71760 328440 0 0 $X=71580 $Y=328175
X4422 VSS: 2 VSS: 321 1090 2 BUFX8 $T=83720 328440 1 180 $X=78480 $Y=328175
X4425 VSS: 2 VSS: 832 636 836 2 NAND2X2_HS $T=68540 336720 1 0 $X=68360 $Y=332275
X4428 VSS: 2 VSS: 834 635 2 CLKINVX2 $T=74520 336720 1 0 $X=74340 $Y=332275
X4431 VSS: 2 VSS: 835 419 837 2 NAND2X2 $T=78660 336720 1 0 $X=78480 $Y=332275
X4435 VSS: 2 VSS: 830 639 838 839 627 2 OAI22X2_HS $T=76360 336720 1 180 $X=70660 $Y=336455
X4440 VSS: 2 VSS: 836 639 838 839 627 2 OAI22X2_HS $T=67620 345000 1 0 $X=67440 $Y=340555
X4444 VSS: 2 VSS: 839 840 2 CLKINVX2_HS $T=79120 345000 1 0 $X=78940 $Y=340555
X4445 VSS: 2 VSS: 843 647 642 2 NAND2X1 $T=65780 345000 0 0 $X=65600 $Y=344735
X4448 VSS: 2 VSS: 499 842 2 CLKBUFX4 $T=71760 345000 1 180 $X=68820 $Y=344735
X4452 VSS: 2 VSS: 838 648 2 CLKINVX2 $T=76360 345000 1 180 $X=74800 $Y=344735
X4456 VSS: 2 VSS: 841 635 2 CLKINVX2 $T=79580 345000 0 0 $X=79400 $Y=344735
X4460 VSS: 2 VSS: 846 32 845 843 2 AOI21X1 $T=70380 353280 0 180 $X=67900 $Y=348835
X4462 VSS: 2 VSS: 845 32 33 843 2 OAI21X1 $T=72220 353280 1 0 $X=72040 $Y=348835
X4465 VSS: 2 VSS: 297 844 2 CLKINVX4 $T=77280 353280 1 0 $X=77100 $Y=348835
X4468 VSS: 2 VSS: 849 846 223 2 NAND2X2 $T=69000 353280 1 180 $X=66520 $Y=353015
X4471 VSS: 2 VSS: 32 456 848 2 NAND2X2_HS $T=74520 353280 1 180 $X=71120 $Y=353015
X4473 VSS: 2 VSS: 848 847 2 CLKINVX1 $T=80960 353280 1 180 $X=79400 $Y=353015
X4477 VSS: 2 VSS: 31 850 456 2 OR2X1 $T=74520 361560 1 0 $X=74340 $Y=357115
X4480 VSS: 2 VSS: 850 847 2 CLKINVX1 $T=79580 361560 0 180 $X=78020 $Y=357115
X4484 VSS: 2 VSS: 852 230 854 655 2 OAI21X1_HS $T=67160 361560 0 0 $X=66980 $Y=361295
X4487 VSS: 2 VSS: 657 656 855 2 NAND2X4_HS $T=75440 361560 0 0 $X=75260 $Y=361295
X4490 VSS: 2 VSS: 854 856 2 INVX2 $T=66700 369840 1 0 $X=66520 $Y=365395
X4494 VSS: 2 VSS: 855 230 30 456 223 2 AOI22X2_HS $T=74520 369840 1 0 $X=74340 $Y=365395
X4496 VSS: 2 VSS: 851 456 27 856 2 NAND3X1_HS $T=69460 369840 1 180 $X=66520 $Y=369575
X4501 VSS: 2 VSS: 859 858 857 2 NOR2X2_HS $T=81420 369840 1 180 $X=78020 $Y=369575
X4505 VSS: 2 VSS: 452 860 857 2 NAND2X4_HS $T=74060 378120 0 180 $X=68820 $Y=373675
X4508 VSS: 2 VSS: 223 859 2 CLKBUFX8_HS $T=75440 378120 1 0 $X=75260 $Y=373675
X4509 VSS: 2 VSS: 661 451 861 2 AND2X1_HS $T=69920 378120 1 180 $X=66980 $Y=377855
X4511 VSS: 2 VSS: 861 853 2 CLKBUFX2 $T=73140 378120 1 180 $X=70660 $Y=377855
X4513 VSS: 2 VSS: 860 862 2 BUFX2 $T=77280 378120 1 180 $X=74800 $Y=377855
X4516 VSS: 2 VSS: 639 1119 2 BUFX16_HS $T=88780 378120 1 180 $X=78480 $Y=377855
X4521 VSS: 2 VSS: 451 862 863 2 CLKAND2X2 $T=75440 386400 0 180 $X=72960 $Y=381955
X4525 VSS: 2 VSS: 858 862 2 CLKINVX2_HS $T=80500 386400 1 0 $X=80320 $Y=381955
X4528 VSS: 2 VSS: 667 451 864 2 AND2X1 $T=73600 386400 1 180 $X=71120 $Y=386135
X4532 VSS: 2 VSS: 863 424 2 INVX1 $T=80960 386400 1 180 $X=79400 $Y=386135
X4539 VSS: 2 VSS: 1106 865 1125 2 NAND2X4_HS $T=81420 394680 1 0 $X=81240 $Y=390235
X4541 VSS: 2 VSS: 864 669 2 BUFX8_HS $T=69920 394680 0 0 $X=69740 $Y=394415
X4545 VSS: 2 VSS: 867 863 858 2 NAND2X1_HS $T=78660 394680 0 0 $X=78480 $Y=394415
X4551 VSS: 2 VSS: 870 2 TIELO $T=80500 402960 0 180 $X=78940 $Y=398515
X4555 VSS: 2 VSS: 842 872 871 2 NOR2X1 $T=67620 402960 0 0 $X=67440 $Y=402695
X4559 VSS: 2 VSS: 844 871 873 2 NAND2X2 $T=75440 402960 0 0 $X=75260 $Y=402695
X4563 VSS: 2 VSS: 872 873 2 CLKINVX1 $T=69460 411240 0 180 $X=67900 $Y=406795
X4565 VSS: 2 VSS: 873 875 2 CLKINVX2 $T=74520 411240 0 180 $X=72960 $Y=406795
X4569 VSS: 2 VSS: 875 876 874 869 2 NAND3X1_HS $T=80500 411240 1 0 $X=80320 $Y=406795
X4573 VSS: 2 VSS: 877 871 2 CLKINVX2 $T=76820 411240 0 0 $X=76640 $Y=410975
X4578 VSS: 2 VSS: 33 879 2 INVX8_HS $T=73140 419520 0 180 $X=67900 $Y=415075
X4581 VSS: 2 VSS: 879 877 878 2 NAND2X2_HS $T=77740 419520 1 0 $X=77560 $Y=415075
X4586 VSS: 2 VSS: 880 881 2 INVX2_HS $T=72680 419520 0 0 $X=72500 $Y=419255
X4589 VSS: 2 VSS: 878 882 1129 2 NOR2X2_HS $T=79580 419520 0 0 $X=79400 $Y=419255
X4591 VSS: 2 VSS: 881 887 690 884 2 NAND3X1_HS $T=74980 427800 0 180 $X=72040 $Y=423355
X4594 VSS: 2 VSS: 885 886 2 INVX2_HS $T=79580 427800 1 0 $X=79400 $Y=423355
X4596 VSS: 2 VSS: 888 691 883 890 889 2 NAND4X1_HS $T=69920 427800 1 180 $X=66520 $Y=427535
X4600 VSS: 2 VSS: 1133 888 891 892 2 OAI21X2_HS $T=79120 427800 0 0 $X=78940 $Y=427535
X4605 VSS: 2 VSS: 891 693 893 887 894 2 NAND4X2_HS $T=82800 436080 0 180 $X=77100 $Y=431635
X4608 VSS: 2 VSS: 889 694 2 CLKINVX1_HS $T=71760 436080 1 180 $X=68820 $Y=435815
X4613 VSS: 2 VSS: 893 691 690 2 NOR2X1_HS $T=78660 436080 0 0 $X=78480 $Y=435815
X4618 VSS: 2 VSS: 884 890 700 2 NAND2X2_HS $T=70840 444360 1 0 $X=70660 $Y=439915
X4621 VSS: 2 VSS: 894 890 2 CLKINVX2 $T=80040 444360 0 180 $X=78480 $Y=439915
X4624 VSS: 2 VSS: 895 690 702 2 AND2X1 $T=66700 444360 0 0 $X=66520 $Y=444095
X4629 VSS: 2 VSS: 900 892 2 BUFX2_HS $T=81880 444360 0 0 $X=81700 $Y=444095
X4630 VSS: 2 VSS: 896 897 898 895 2 NAND3X2_HS $T=70380 452640 0 180 $X=65600 $Y=448195
X4634 VSS: 2 VSS: 898 899 894 2 NOR2X1 $T=80040 452640 0 180 $X=78020 $Y=448195
X4638 VSS: 2 VSS: 897 900 2 INVX2 $T=69460 452640 1 180 $X=67900 $Y=452375
X4647 VSS: 2 VSS: 577 903 2 BUFX8_HS $T=83720 460920 0 180 $X=78020 $Y=456475
X4653 VSS: 2 VSS: 901 1149 2 BUFX16_HS $T=92000 460920 1 180 $X=81700 $Y=460655
X4654 VSS: 2 VSS: 906 905 904 2 NOR2X2_HS $T=68540 469200 1 0 $X=68360 $Y=464755
X4658 VSS: 2 VSS: 903 906 902 2 NAND2X2_HS $T=79580 469200 1 0 $X=79400 $Y=464755
X4665 VSS: 2 VSS: 907 911 910 908 909 2 NAND4X2_HS $T=75440 477480 0 180 $X=69740 $Y=473035
X4669 VSS: 2 VSS: 911 912 913 914 901 2 AOI22X2_HS $T=71760 477480 1 180 $X=66060 $Y=477215
X4675 VSS: 2 VSS: 910 704 916 917 705 2 AOI22X2 $T=74520 485760 0 180 $X=69740 $Y=481315
X4685 VSS: 2 VSS: 908 918 920 921 919 2 AOI22X2 $T=70840 494040 1 0 $X=70660 $Y=489595
X4689 VSS: 2 VSS: 909 925 923 924 926 2 AOI22X2_HS $T=67160 494040 0 0 $X=66980 $Y=493775
X4695 VSS: 2 VSS: 930 929 921 920 928 2 AOI22X1 $T=70840 502320 1 0 $X=70660 $Y=497875
X4700 VSS: 2 VSS: 905 931 932 933 930 2 NAND4X1_HS $T=69000 502320 0 0 $X=68820 $Y=502055
X4705 VSS: 2 VSS: 933 935 924 923 934 2 AOI22X1 $T=67620 510600 1 0 $X=67440 $Y=506155
X4711 VSS: 2 VSS: 707 918 936 937 919 2 AOI22X2_HS $T=67620 510600 0 0 $X=67440 $Y=510335
X4717 VSS: 2 VSS: 938 928 936 937 929 2 AOI22X2_HS $T=68080 518880 1 0 $X=67900 $Y=514435
X4722 VSS: 2 VSS: 932 939 917 916 940 2 AOI22X2_HS $T=69000 518880 0 0 $X=68820 $Y=518615
X4737 VSS: 2 VSS: 946 940 945 1178 939 2 AOI22X2_HS $T=83260 535440 0 180 $X=77560 $Y=530995
X4739 VSS: 2 VSS: 931 947 913 914 703 2 AOI22X1_HS $T=67160 535440 0 0 $X=66980 $Y=535175
X4750 VSS: 2 VSS: 1181 704 945 1178 705 2 AOI22X2_HS $T=81420 543720 1 0 $X=81240 $Y=539275
X4759 VSS: 2 VSS: 952 950 953 1181 1173 2 NAND4X4_HS $T=78200 552000 1 0 $X=78020 $Y=547555
X4767 VSS: 2 VSS: 953 912 1185 958 901 2 AOI22X2_HS $T=80500 560280 1 0 $X=80320 $Y=555835
X4768 VSS: 2 VSS: 959 703 957 956 947 2 AOI22X2_HS $T=66700 560280 0 0 $X=66520 $Y=560015
X4773 VSS: 2 VSS: 961 938 943 951 959 2 NAND4X2_HS $T=67160 568560 1 0 $X=66980 $Y=564115
X4789 VSS: 2 VSS: 448 1193 2 BUFX8_HS $T=85560 576840 1 180 $X=79860 $Y=576575
X4793 VSS: 2 VSS: 964 966 963 2 NAND2X4_HS $T=79580 585120 0 180 $X=74340 $Y=580675
X4795 VSS: 2 VSS: 1193 1198 965 2 NAND2X2_HS $T=84640 585120 0 180 $X=81240 $Y=580675
X4800 VSS: 2 VSS: 966 952 968 2 NOR2X4_HS $T=77280 585120 0 0 $X=77100 $Y=584855
X4852 VSS: 2 VSS: 967 971 972 970 969 2 NAND4X4_HS $T=74060 643080 1 0 $X=73880 $Y=638635
X4887 VSS: 2 VSS: 973 757 505 725 731 2 AOI22X1 $T=82800 30360 1 0 $X=82620 $Y=25915
X4895 VSS: 2 VSS: 978 974 710 973 2 NAND3X1_HS $T=88320 30360 1 180 $X=85380 $Y=30095
X4896 VSS: 2 VSS: 975 978 2 CLKINVX2_HS $T=88320 30360 0 0 $X=88140 $Y=30095
X4899 VSS: 2 VSS: 974 976 1220 556 977 2 AOI22X1 $T=98900 30360 1 180 $X=95960 $Y=30095
X4911 VSS: 2 VSS: 980 544 977 508 976 2 AOI22X1 $T=86940 38640 1 180 $X=84000 $Y=38375
X4933 VSS: 2 VSS: 281 274 299 2 NAND2X2 $T=98440 46920 0 0 $X=98260 $Y=46655
X4946 VSS: 2 VSS: 731 709 982 294 983 2 NAND4X2_HS $T=84180 55200 0 0 $X=84000 $Y=54935
X4949 VSS: 2 VSS: 985 981 984 2 CLKAND2X2 $T=92460 55200 0 0 $X=92280 $Y=54935
X4957 VSS: 2 VSS: 724 987 501 2 NOR2X1_HS $T=84180 63480 1 0 $X=84000 $Y=59035
X4960 VSS: 2 VSS: 986 517 985 983 2 NAND3X4_HS $T=93840 63480 1 0 $X=93660 $Y=59035
X4967 VSS: 2 VSS: 988 291 276 2 NAND2X1 $T=89700 63480 0 0 $X=89520 $Y=63215
X4970 VSS: 2 VSS: 72 986 2 CLKINVX4_HS $T=97060 63480 0 0 $X=96880 $Y=63215
X4975 VSS: 2 VSS: 989 501 2 INVX4_HS $T=86940 71760 1 0 $X=86760 $Y=67315
X4979 VSS: 2 VSS: 984 292 299 2 NAND2X2_HS $T=101660 71760 0 180 $X=98260 $Y=67315
X4986 VSS: 2 VSS: 737 518 300 988 984 2 NAND4X1_HS $T=92920 71760 1 180 $X=89520 $Y=71495
X4995 VSS: 2 VSS: 990 757 505 987 737 2 AOI22X1 $T=89700 80040 1 0 $X=89520 $Y=75595
X5001 VSS: 2 VSS: 991 531 2 CLKINVX2 $T=83720 80040 0 0 $X=83540 $Y=79775
X5006 VSS: 2 VSS: 1236 735 2 BUFX2_HS $T=96600 80040 0 0 $X=96420 $Y=79775
X5012 VSS: 2 VSS: 992 737 757 2 NAND2X1 $T=89700 88320 1 0 $X=89520 $Y=83875
X5021 VSS: 2 VSS: 993 736 2 CLKBUFX2 $T=86020 88320 0 0 $X=85840 $Y=88055
X5026 VSS: 2 VSS: 1240 515 2 CLKINVX1 $T=99820 88320 1 180 $X=98260 $Y=88055
X5035 VSS: 2 VSS: 995 1240 581 587 993 2 OAI22X1_HS $T=99820 96600 0 180 $X=96420 $Y=92155
X5041 VSS: 2 VSS: 997 340 539 712 505 2 AOI22X1_HS $T=84640 96600 0 0 $X=84460 $Y=96335
X5045 VSS: 2 VSS: 1237 996 63 340 995 2 AOI211X2_HS $T=101200 96600 1 180 $X=95500 $Y=96335
X5050 VSS: 2 VSS: 999 508 2 CLKINVX2 $T=83260 104880 1 0 $X=83080 $Y=100435
X5053 VSS: 2 VSS: 1000 747 2 CLKINVX2 $T=87400 104880 1 0 $X=87220 $Y=100435
X5056 VSS: 2 VSS: 996 747 998 2 NOR2X1 $T=91080 104880 1 0 $X=90900 $Y=100435
X5059 VSS: 2 VSS: 1246 999 1245 747 997 2 OAI211X2_HS $T=97520 104880 1 0 $X=97340 $Y=100435
X5065 VSS: 2 VSS: 1002 340 712 505 1000 2 AOI22X2_HS $T=85100 104880 0 0 $X=84920 $Y=104615
X5069 VSS: 2 VSS: 1003 581 1001 999 1002 2 OAI211X2_HS $T=99360 104880 1 180 $X=93660 $Y=104615
X5074 VSS: 2 VSS: 37 757 505 290 151 2 AOI22X1 $T=86020 113160 1 0 $X=85840 $Y=108715
X5077 VSS: 2 VSS: 1001 393 1004 2 NAND2X1 $T=94300 113160 1 0 $X=94120 $Y=108715
X5082 VSS: 2 VSS: 1006 539 757 2 AND2X1 $T=83260 113160 0 0 $X=83080 $Y=112895
X5086 VSS: 2 VSS: 1007 1005 1006 2 OR2X1_HS $T=94760 113160 0 0 $X=94580 $Y=112895
X5092 VSS: 2 VSS: 1009 1010 749 2 OR2X1_HS $T=83720 121440 1 0 $X=83540 $Y=116995
X5093 VSS: 2 VSS: 1008 764 1009 2 NOR2X4_HS $T=91540 121440 0 180 $X=86300 $Y=116995
X5097 VSS: 2 VSS: 1005 587 1253 769 70 2 OAI22X1 $T=97980 121440 1 0 $X=97800 $Y=116995
X5103 VSS: 2 VSS: 1010 600 536 399 71 2 OAI22X1_HS $T=87860 121440 1 180 $X=84460 $Y=121175
X5109 VSS: 2 VSS: 1011 151 757 2 AND2X1_HS $T=101200 121440 1 180 $X=98260 $Y=121175
X5118 VSS: 2 VSS: 1012 1236 71 1023 718 2 OAI22X1 $T=100740 129720 0 180 $X=97800 $Y=125275
X5125 VSS: 2 VSS: 1014 1013 975 2 CLKAND2X2 $T=86940 129720 0 0 $X=86760 $Y=129455
X5129 VSS: 2 VSS: 1257 1012 1011 2 OR2X1_HS $T=98440 129720 0 0 $X=98260 $Y=129455
X5137 VSS: 2 VSS: 755 70 1015 72 769 2 OAI22X1 $T=95220 138000 0 180 $X=92280 $Y=133555
X5145 VSS: 2 VSS: 1017 756 1016 2 NOR2X2_HS $T=88320 138000 1 180 $X=84920 $Y=137735
X5167 VSS: 2 VSS: 38 174 508 712 189 2 AOI22X1 $T=82800 154560 1 0 $X=82620 $Y=150115
X5178 VSS: 2 VSS: 1018 766 1019 519 1020 2 OAI211X1 $T=93380 154560 0 0 $X=93200 $Y=154295
X5184 VSS: 2 VSS: 36 1022 393 556 1021 2 AOI22X2 $T=93840 162840 0 180 $X=89060 $Y=158395
X5192 VSS: 2 VSS: 1021 1024 2 CLKINVX2 $T=85560 162840 1 180 $X=84000 $Y=162575
X5196 VSS: 2 VSS: 1024 1023 2 CLKBUFX2 $T=93840 162840 1 180 $X=91360 $Y=162575
X5203 VSS: 2 VSS: 1020 508 375 2 NAND2X1 $T=82800 171120 1 0 $X=82620 $Y=166675
X5207 VSS: 2 VSS: 1025 509 2 CLKINVX2 $T=91080 171120 1 0 $X=90900 $Y=166675
X5210 VSS: 2 VSS: 1022 718 2 CLKINVX1 $T=97980 171120 0 180 $X=96420 $Y=166675
X5216 VSS: 2 VSS: 763 508 574 2 NAND2X1 $T=82800 171120 0 0 $X=82620 $Y=170855
X5219 VSS: 2 VSS: 1026 555 989 743 353 2 AOI22X2_HS $T=92000 171120 0 0 $X=91820 $Y=170855
X5228 VSS: 2 VSS: 759 743 559 2 NAND2X1 $T=91540 179400 1 0 $X=91360 $Y=174955
X5237 VSS: 2 VSS: 1028 505 768 189 1027 2 AOI211X1 $T=83720 179400 0 0 $X=83540 $Y=179135
X5242 VSS: 2 VSS: 1029 770 2 INVX2 $T=99360 179400 1 180 $X=97800 $Y=179135
X5247 VSS: 2 VSS: 1030 1031 1028 2 AND2X1_HS $T=84180 187680 1 0 $X=84000 $Y=183235
X5252 VSS: 2 VSS: 1031 1029 1032 2 NAND2X1_HS $T=97980 187680 0 180 $X=95500 $Y=183235
X5258 VSS: 2 VSS: 1027 769 790 6 999 2 OAI22X1 $T=86020 187680 1 180 $X=83080 $Y=187415
X5267 VSS: 2 VSS: 1033 736 2 BUFX2 $T=85560 195960 1 0 $X=85380 $Y=191515
X5271 VSS: 2 VSS: 1273 1236 73 1019 353 2 OAI22X2_HS $T=101200 195960 0 180 $X=95500 $Y=191515
X5280 VSS: 2 VSS: 1035 1034 1033 1023 718 2 OAI22X1 $T=97060 195960 1 180 $X=94120 $Y=195695
X5287 VSS: 2 VSS: 1036 519 998 2 NOR2X1 $T=83720 204240 1 0 $X=83540 $Y=199795
X5291 VSS: 2 VSS: 1037 591 1036 330 1035 2 AOI211X1_HS $T=96600 204240 0 180 $X=93200 $Y=199795
X5292 VSS: 2 VSS: 1032 1037 2 CLKINVX1 $T=96600 204240 1 0 $X=96420 $Y=199795
X5298 VSS: 2 VSS: 1013 776 775 2 OR2X1 $T=86480 204240 0 0 $X=86300 $Y=203975
X5301 VSS: 2 VSS: 1040 1037 1038 298 1039 2 OAI211X1_HS $T=92920 204240 0 0 $X=92740 $Y=203975
X5302 VSS: 2 VSS: 1276 1040 2 BUFX4_HS $T=96140 204240 0 0 $X=95960 $Y=203975
X5310 VSS: 2 VSS: 1041 1042 775 2 OR2X1 $T=93840 212520 1 0 $X=93660 $Y=208075
X5318 VSS: 2 VSS: 1043 1042 2 CLKINVX1 $T=88320 212520 0 0 $X=88140 $Y=212255
X5323 VSS: 2 VSS: 1044 770 2 INVX4 $T=96600 212520 0 0 $X=96420 $Y=212255
X5331 VSS: 2 VSS: 1019 784 2 BUFX2 $T=88780 220800 1 0 $X=88600 $Y=216355
X5334 VSS: 2 VSS: 41 1019 578 2 NOR2X2_HS $T=96600 220800 1 0 $X=96420 $Y=216355
X5338 VSS: 2 VSS: 1015 575 2 CLKINVX2 $T=84640 220800 0 0 $X=84460 $Y=220535
X5342 VSS: 2 VSS: 393 1046 2 CLKINVX8 $T=93380 220800 1 180 $X=89060 $Y=220535
X5345 VSS: 2 VSS: 1046 1045 1044 2 NAND2X4_HS $T=101200 220800 1 180 $X=95960 $Y=220535
X5354 VSS: 2 VSS: 1045 1282 2 INVX4_HS $T=99820 229080 0 180 $X=96420 $Y=224635
X5360 VSS: 2 VSS: 1047 1048 588 4 6 2 OAI22X1_HS $T=87860 229080 1 180 $X=84460 $Y=228815
X5364 VSS: 2 VSS: 1038 393 1049 1050 1047 2 AOI211X1_HS $T=97060 229080 1 180 $X=93660 $Y=228815
X5373 VSS: 2 VSS: 1051 588 1015 2 OR2X1_HS $T=95220 237360 1 0 $X=95040 $Y=232915
X5382 VSS: 2 VSS: 1049 802 399 356 371 2 OAI22X1 $T=92460 237360 0 0 $X=92280 $Y=237095
X5390 VSS: 2 VSS: 1050 209 2 CLKBUFX2 $T=91540 245640 1 0 $X=91360 $Y=241195
X5396 VSS: 2 VSS: 791 6 2 CLKINVX2 $T=85560 245640 1 180 $X=84000 $Y=245375
X5400 VSS: 2 VSS: 1292 800 1023 399 356 2 OAI22X2_HS $T=96600 245640 0 0 $X=96420 $Y=245375
X5408 VSS: 2 VSS: 1053 1292 2 INVX2_HS $T=97520 253920 1 0 $X=97340 $Y=249475
X5414 VSS: 2 VSS: 797 71 2 INVX2 $T=86480 253920 1 180 $X=84920 $Y=253655
X5418 VSS: 2 VSS: 1055 519 2 INVX2_HS $T=92000 253920 1 180 $X=89520 $Y=253655
X5420 VSS: 2 VSS: 796 371 2 INVX4_HS $T=93840 253920 0 0 $X=93660 $Y=253655
X5429 VSS: 2 VSS: 1056 1055 619 2 NAND2X1_HS $T=89700 262200 1 0 $X=89520 $Y=257755
X5437 VSS: 2 VSS: 1058 718 2 INVX4_HS $T=92460 262200 1 180 $X=89060 $Y=261935
X5441 VSS: 2 VSS: 1299 1056 1053 2 NAND2X2_HS $T=97520 262200 0 0 $X=97340 $Y=261935
X5445 VSS: 2 VSS: 1059 601 1058 2 NAND2X2_HS $T=82800 270480 1 0 $X=82620 $Y=266035
X5451 VSS: 2 VSS: 1300 621 1302 1052 1060 2 OAI211X1_HS $T=96600 270480 1 0 $X=96420 $Y=266035
X5455 VSS: 2 VSS: 1061 795 798 1059 609 2 NAND4X2_HS $T=88320 270480 1 180 $X=82620 $Y=270215
X5460 VSS: 2 VSS: 1060 1299 1061 2 NOR2X2_HS $T=101660 270480 1 180 $X=98260 $Y=270215
X5465 VSS: 2 VSS: 778 1057 2 CLKINVX2 $T=89700 278760 0 180 $X=88140 $Y=274315
X5467 VSS: 2 VSS: 71 393 2 CLKINVX8 $T=97520 278760 0 180 $X=93200 $Y=274315
X5474 VSS: 2 VSS: 601 801 2 INVX4_HS $T=86940 278760 1 180 $X=83540 $Y=278495
X5477 VSS: 2 VSS: 1063 71 2 CLKBUFX2 $T=90620 278760 1 180 $X=88140 $Y=278495
X5480 VSS: 2 VSS: 597 1062 2 BUFX8_HS $T=97520 278760 1 180 $X=91820 $Y=278495
X5481 VSS: 2 VSS: 515 1307 2 INVX4_HS $T=100740 278760 1 180 $X=97340 $Y=278495
X5486 VSS: 2 VSS: 808 600 804 1064 1063 2 OAI22X1_HS $T=91540 287040 0 180 $X=88140 $Y=282595
X5489 VSS: 2 VSS: 1308 744 2 BUFX2 $T=97060 287040 1 0 $X=96880 $Y=282595
X5494 VSS: 2 VSS: 811 1065 810 118 2 MX2X1_HS $T=86940 287040 1 180 $X=82620 $Y=286775
X5496 VSS: 2 VSS: 619 1064 2 INVX4 $T=89700 287040 1 180 $X=87220 $Y=286775
X5498 VSS: 2 VSS: 1066 810 2 BUFX4_HS $T=91540 287040 0 0 $X=91360 $Y=286775
X5506 VSS: 2 VSS: 274 1069 2 BUFX4_HS $T=89700 295320 0 180 $X=85840 $Y=290875
X5510 VSS: 2 VSS: 1302 817 82 1067 1068 2 OAI211X1_HS $T=95680 295320 1 0 $X=95500 $Y=290875
X5515 VSS: 2 VSS: 1072 1071 2 INVX1 $T=90160 295320 0 0 $X=89980 $Y=295055
X5519 VSS: 2 VSS: 1068 817 1067 2 NAND2X1_HS $T=96600 295320 0 0 $X=96420 $Y=295055
X5525 VSS: 2 VSS: 51 1071 1073 2 NAND2X1 $T=86940 303600 0 180 $X=84920 $Y=299155
X5529 VSS: 2 VSS: 1067 1073 1072 52 2 AOI21X1_HS $T=96140 303600 1 0 $X=95960 $Y=299155
X5535 VSS: 2 VSS: 1071 1075 2 CLKBUFX2 $T=87400 303600 0 0 $X=87220 $Y=303335
X5538 VSS: 2 VSS: 620 1074 82 2 NAND2X4_HS $T=97520 303600 1 180 $X=92280 $Y=303335
X5545 VSS: 2 VSS: 1077 1075 822 823 2 OAI21X2_HS $T=85100 311880 1 0 $X=84920 $Y=307435
X5549 VSS: 2 VSS: 825 1078 1076 52 2 AOI21X2_HS $T=96140 311880 1 0 $X=95960 $Y=307435
X5557 VSS: 2 VSS: 1082 1077 2 INVX1 $T=90160 311880 0 0 $X=89980 $Y=311615
X5560 VSS: 2 VSS: 1081 1080 2 CLKINVX1 $T=96140 311880 0 0 $X=95960 $Y=311615
X5566 VSS: 2 VSS: 1080 823 829 2 NOR2X4_HS $T=90160 320160 0 180 $X=84920 $Y=315715
X5570 VSS: 2 VSS: 1076 1081 1083 2 NOR2X1 $T=96140 320160 1 0 $X=95960 $Y=315715
X5576 VSS: 2 VSS: 1073 829 2 CLKINVX1 $T=85560 320160 0 0 $X=85380 $Y=319895
X5580 VSS: 2 VSS: 1078 1085 1084 1082 2 OAI21X1_HS $T=94760 320160 1 180 $X=91820 $Y=319895
X5588 VSS: 2 VSS: 1085 1087 1086 2 NOR2X2_HS $T=92460 328440 0 180 $X=89060 $Y=323995
X5589 VSS: 2 VSS: 1087 419 2 BUFX2_HS $T=95220 328440 0 180 $X=92280 $Y=323995
X5592 VSS: 2 VSS: 1083 1085 2 BUFX2 $T=98900 328440 0 180 $X=96420 $Y=323995
X5598 VSS: 2 VSS: 1086 834 1091 1092 2 OAI21X2_HS $T=85560 328440 0 0 $X=85380 $Y=328175
X5601 VSS: 2 VSS: 1088 1093 1089 2 NAND2X1 $T=96140 328440 1 180 $X=94120 $Y=328175
X5607 VSS: 2 VSS: 837 834 1091 1092 2 OAI21X2_HS $T=84640 336720 1 0 $X=84460 $Y=332275
X5610 VSS: 2 VSS: 1084 835 2 BUFX2 $T=91540 336720 1 0 $X=91360 $Y=332275
X5613 VSS: 2 VSS: 1317 835 1094 1107 2 OAI21X2_HS $T=96600 336720 1 0 $X=96420 $Y=332275
X5619 VSS: 2 VSS: 1092 639 1095 1096 627 2 OAI22X2_HS $T=84180 336720 0 0 $X=84000 $Y=336455
X5622 VSS: 2 VSS: 1093 835 2 BUFX2 $T=94300 336720 0 0 $X=94120 $Y=336455
X5628 VSS: 2 VSS: 824 1099 1100 2 NAND2X1 $T=86480 345000 0 180 $X=84460 $Y=340555
X5630 VSS: 2 VSS: 1096 1097 2 CLKINVX2_HS $T=87400 345000 1 0 $X=87220 $Y=340555
X5632 VSS: 2 VSS: 1099 1094 2 CLKBUFX2 $T=94300 345000 0 180 $X=91820 $Y=340555
X5635 VSS: 2 VSS: 82 1098 2 CLKBUFX4 $T=97060 345000 1 0 $X=96880 $Y=340555
X5641 VSS: 2 VSS: 1091 1101 1104 841 2 NAND3X2_HS $T=84180 345000 0 0 $X=84000 $Y=344735
X5645 VSS: 2 VSS: 1100 1102 2 CLKINVX1 $T=93380 345000 1 180 $X=91820 $Y=344735
X5648 VSS: 2 VSS: 1057 840 1103 2 NAND2X4_HS $T=101200 345000 1 180 $X=95960 $Y=344735
X5652 VSS: 2 VSS: 1104 627 1105 2 NAND2X2_HS $T=85560 353280 0 180 $X=82160 $Y=348835
X5656 VSS: 2 VSS: 627 1106 2 BUFX2 $T=91080 353280 0 180 $X=88600 $Y=348835
X5659 VSS: 2 VSS: 1102 1107 2 CLKBUFX2 $T=96140 353280 0 180 $X=93660 $Y=348835
X5666 VSS: 2 VSS: 1101 1105 1108 2 NAND2X2_HS $T=83720 353280 0 0 $X=83540 $Y=353015
X5668 VSS: 2 VSS: 1108 1097 2 CLKINVX2_HS $T=87860 353280 0 0 $X=87680 $Y=353015
X5671 VSS: 2 VSS: 1107 1110 1109 2 NOR2X4_HS $T=98900 353280 1 180 $X=93660 $Y=353015
X5675 VSS: 2 VSS: 1105 639 1095 2 OR2X2_HS $T=85560 361560 0 180 $X=82160 $Y=357115
X5677 VSS: 2 VSS: 1095 449 2 INVX1 $T=90620 361560 0 180 $X=89060 $Y=357115
X5680 VSS: 2 VSS: 1094 426 1109 2 NAND2X1_HS $T=97060 361560 0 180 $X=94580 $Y=357115
X5686 VSS: 2 VSS: 1111 635 2 CLKINVX2 $T=85100 361560 0 0 $X=84920 $Y=361295
X5690 VSS: 2 VSS: 1109 1111 1112 1113 2 OAI21X2_HS $T=92920 361560 0 0 $X=92740 $Y=361295
X5699 VSS: 2 VSS: 1113 1114 639 1115 1106 2 OAI22X2_HS $T=92460 369840 1 0 $X=92280 $Y=365395
X5707 VSS: 2 VSS: 1114 241 2 INVX1 $T=89240 369840 0 0 $X=89060 $Y=369575
X5709 VSS: 2 VSS: 1116 1114 639 1115 1106 2 OAI22X2_HS $T=91080 369840 0 0 $X=90900 $Y=369575
X5710 VSS: 2 VSS: 1115 1117 2 CLKINVX2_HS $T=96600 369840 0 0 $X=96420 $Y=369575
X5718 VSS: 2 VSS: 662 870 1118 867 2 ICGPRECX1 $T=101660 378120 0 180 $X=92740 $Y=373675
X5725 VSS: 2 VSS: 1112 1120 1116 2 NAND2X2_HS $T=96140 378120 1 180 $X=92740 $Y=377855
X5733 VSS: 2 VSS: 1098 1122 1106 2 NAND2X1 $T=89240 386400 0 180 $X=87220 $Y=381955
X5736 VSS: 2 VSS: 635 1121 2 BUFX16_HS $T=92000 386400 1 0 $X=91820 $Y=381955
X5741 VSS: 2 VSS: 1119 1123 1124 2 NAND2X2_HS $T=88320 386400 1 180 $X=84920 $Y=386135
X5744 VSS: 2 VSS: 1124 1122 2 INVX2 $T=91080 386400 0 0 $X=90900 $Y=386135
X5754 VSS: 2 VSS: 1125 1123 2 INVX2 $T=94300 394680 0 180 $X=92740 $Y=390235
X5763 VSS: 2 VSS: 865 1126 2 INVX2 $T=89240 394680 1 180 $X=87680 $Y=394415
X5767 VSS: 2 VSS: 1127 1126 1123 2 NOR2X4_HS $T=99360 394680 1 180 $X=94120 $Y=394415
X5773 VSS: 2 VSS: 1126 869 2 CLKINVX2 $T=86940 402960 1 0 $X=86760 $Y=398515
X5776 VSS: 2 VSS: 1121 1128 1127 2 CLKAND2X2 $T=96140 402960 0 180 $X=93660 $Y=398515
X5782 VSS: 2 VSS: 874 1129 2 CLKINVX1 $T=84180 402960 1 180 $X=82620 $Y=402695
X5785 VSS: 2 VSS: 1122 869 1129 2 NAND2X2_HS $T=88780 402960 0 0 $X=88600 $Y=402695
X5788 VSS: 2 VSS: 1129 1128 2 CLKBUFX2_HS $T=99820 402960 1 180 $X=96420 $Y=402695
X5795 VSS: 2 VSS: 869 1131 2 CLKINVX2 $T=90160 411240 0 180 $X=88600 $Y=406795
X5798 VSS: 2 VSS: 1130 876 2 CLKBUFX2 $T=92920 411240 1 0 $X=92740 $Y=406795
X5802 VSS: 2 VSS: 1372 1377 1378 1128 1130 2 NOR4X1 $T=98440 411240 1 0 $X=98260 $Y=406795
X5806 VSS: 2 VSS: 876 1133 2 BUFX2_HS $T=82800 411240 0 0 $X=82620 $Y=410975
X5808 VSS: 2 VSS: 1123 1132 871 2 NAND2X4_HS $T=89240 411240 0 0 $X=89060 $Y=410975
X5816 VSS: 2 VSS: 1132 876 2 INVX4_HS $T=87400 419520 1 0 $X=87220 $Y=415075
X5820 VSS: 2 VSS: 871 1134 2 BUFX2_HS $T=96600 419520 0 180 $X=93660 $Y=415075
X5831 VSS: 2 VSS: 882 1131 1132 2 NAND2X1 $T=89700 419520 0 0 $X=89520 $Y=419255
X5835 VSS: 2 VSS: 1134 1382 1135 2 NAND2X4_HS $T=101660 419520 1 180 $X=96420 $Y=419255
X5840 VSS: 2 VSS: 1135 885 1136 2 NAND2X4_HS $T=84640 427800 1 0 $X=84460 $Y=423355
X5844 VSS: 2 VSS: 892 1137 2 INVX2_HS $T=95220 427800 0 180 $X=92740 $Y=423355
X5852 VSS: 2 VSS: 1136 887 2 CLKBUFX2_HS $T=92000 427800 1 180 $X=88600 $Y=427535
X5855 VSS: 2 VSS: 890 1138 2 INVX4_HS $T=97980 427800 1 180 $X=94580 $Y=427535
X5862 VSS: 2 VSS: 1139 886 2 CLKBUFX2 $T=90160 436080 1 0 $X=89980 $Y=431635
X5866 VSS: 2 VSS: 1382 696 1389 2 NAND2X2_HS $T=98440 436080 1 0 $X=98260 $Y=431635
X5873 VSS: 2 VSS: 1142 1139 1140 2 NAND2X1 $T=91540 436080 1 180 $X=89520 $Y=435815
X5876 VSS: 2 VSS: 1141 890 2 CLKINVX1_HS $T=95680 436080 0 0 $X=95500 $Y=435815
X5884 VSS: 2 VSS: 899 1143 2 CLKINVX2 $T=90160 444360 0 180 $X=88600 $Y=439915
X5892 VSS: 2 VSS: 1144 1145 2 INVX8_HS $T=93380 444360 1 180 $X=88140 $Y=444095
X5895 VSS: 2 VSS: 1393 1069 1144 2 NAND2X2 $T=97520 444360 0 0 $X=97340 $Y=444095
X5902 VSS: 2 VSS: 1146 899 1142 2 CLKAND2X2 $T=89240 452640 1 0 $X=89060 $Y=448195
X5908 VSS: 2 VSS: 1148 900 2 CLKINVX1 $T=84180 452640 0 0 $X=84000 $Y=452375
X5911 VSS: 2 VSS: 1147 1148 1146 2 NAND2X4_HS $T=91080 452640 0 0 $X=90900 $Y=452375
X5921 VSS: 2 VSS: 1396 1069 2 CLKINVX4_HS $T=96600 460920 1 0 $X=96420 $Y=456475
X5933 VSS: 2 VSS: 902 1151 1150 2 NOR2X2_HS $T=90620 469200 1 0 $X=90440 $Y=464755
X5940 VSS: 2 VSS: 1152 1154 927 1155 1153 2 AOI22X2_HS $T=92460 469200 1 180 $X=86760 $Y=468935
X5951 VSS: 2 VSS: 1410 1157 1156 1413 1412 2 AOI22X1_HS $T=98440 477480 1 0 $X=98260 $Y=473035
X5957 VSS: 2 VSS: 1158 960 1155 1153 915 2 AOI22X1 $T=90160 477480 0 0 $X=89980 $Y=477215
X5966 VSS: 2 VSS: 1151 1161 1159 1160 1158 2 NAND4X1_HS $T=90620 485760 1 0 $X=90440 $Y=481315
X5975 VSS: 2 VSS: 1162 960 1163 1164 915 2 AOI22X2 $T=88320 485760 0 0 $X=88140 $Y=485495
X5993 VSS: 2 VSS: 1165 927 1163 1164 1154 2 AOI22X2 $T=89700 494040 0 0 $X=89520 $Y=493775
X6003 VSS: 2 VSS: 1161 1167 1169 1168 1166 2 AOI22X1 $T=93840 502320 0 180 $X=90900 $Y=497875
X6011 VSS: 2 VSS: 1160 1170 1156 1157 1171 2 AOI22X1 $T=93380 502320 1 180 $X=90440 $Y=502055
X6018 VSS: 2 VSS: 1173 918 1172 922 919 2 AOI22X2_HS $T=82800 510600 1 0 $X=82620 $Y=506155
X6040 VSS: 2 VSS: 1174 928 1172 922 929 2 AOI22X2_HS $T=84180 518880 0 0 $X=84000 $Y=518615
X6048 VSS: 2 VSS: 1177 934 1175 1176 935 2 AOI22X2_HS $T=91080 527160 0 180 $X=85380 $Y=522715
X6058 VSS: 2 VSS: 950 925 1175 1176 926 2 AOI22X2_HS $T=90160 527160 0 0 $X=89980 $Y=526895
X6072 VSS: 2 VSS: 1180 946 1174 1177 1179 2 NAND4X4_HS $T=84180 535440 0 0 $X=84000 $Y=535175
X6103 VSS: 2 VSS: 1184 1166 1182 1183 1167 2 AOI22X2_HS $T=96600 552000 1 180 $X=90900 $Y=551735
X6111 VSS: 2 VSS: 1179 703 958 1185 947 2 AOI22X2_HS $T=92000 560280 1 0 $X=91820 $Y=555835
X6121 VSS: 2 VSS: 1454 1444 1450 2 NOR2X2_HS $T=101660 560280 1 180 $X=98260 $Y=560015
X6130 VSS: 2 VSS: 1455 960 1187 1186 915 2 AOI22X2_HS $T=94300 568560 1 0 $X=94120 $Y=564115
X6138 VSS: 2 VSS: 1188 960 1189 1190 915 2 AOI22X2 $T=88320 568560 0 0 $X=88140 $Y=568295
X6147 VSS: 2 VSS: 1191 1154 1190 1189 927 2 AOI22X2_HS $T=92920 576840 0 180 $X=87220 $Y=572395
X6157 VSS: 2 VSS: 1196 960 1192 1194 915 2 AOI22X1_HS $T=90620 576840 0 0 $X=90440 $Y=576575
X6160 VSS: 2 VSS: 1461 1195 1460 2 NAND2X1_HS $T=98440 576840 0 0 $X=98260 $Y=576575
X6165 VSS: 2 VSS: 1198 1197 1200 2 NOR2X2_HS $T=85560 585120 1 0 $X=85380 $Y=580675
X6167 VSS: 2 VSS: 1197 1196 1201 1199 1184 2 NAND4X2_HS $T=90620 585120 1 0 $X=90440 $Y=580675
X6183 VSS: 2 VSS: 1202 1154 927 1187 1186 2 AOI22X2_HS $T=93840 593400 0 180 $X=88140 $Y=588955
X6192 VSS: 2 VSS: 1203 1154 1194 1192 927 2 AOI22X2_HS $T=89700 593400 0 0 $X=89520 $Y=593135
X6200 VSS: 2 VSS: 1201 1171 1204 1205 1170 2 AOI22X2_HS $T=93840 601680 0 180 $X=88140 $Y=597235
X6217 VSS: 2 VSS: 1208 1207 1206 2 NAND2X2 $T=91540 609960 1 0 $X=91360 $Y=605515
X6224 VSS: 2 VSS: 969 1209 1210 2 NAND2X2 $T=84640 609960 1 180 $X=82160 $Y=609695
X6230 VSS: 2 VSS: 1473 955 1475 2 NOR2X4_HS $T=98440 609960 0 0 $X=98260 $Y=609695
X6236 VSS: 2 VSS: 1211 1207 1210 2 NAND2X1 $T=89700 618240 0 180 $X=87680 $Y=613795
X6249 VSS: 2 VSS: 1462 1208 1480 1478 1479 2 NAND4X4_HS $T=96600 618240 0 0 $X=96420 $Y=617975
X6258 VSS: 2 VSS: 1450 1211 1212 1213 2 NAND3X4_HS $T=93840 626520 1 0 $X=93660 $Y=622075
X6284 VSS: 2 VSS: 1213 1484 1214 2 CLKAND2X2 $T=97520 634800 0 0 $X=97340 $Y=634535
X6315 VSS: 2 VSS: 1216 272 190 2 NAND2X1_HS $T=101660 22080 0 0 $X=101480 $Y=21815
X6323 VSS: 2 VSS: 725 1219 1217 1218 1215 2 NAND4X2 $T=113620 30360 0 180 $X=108840 $Y=25915
X6328 VSS: 2 VSS: 1220 1221 2 CLKINVX1 $T=103500 30360 1 180 $X=101940 $Y=30095
X6333 VSS: 2 VSS: 1218 284 275 2 NAND2X1 $T=110400 30360 0 0 $X=110220 $Y=30095
X6336 VSS: 2 VSS: 1224 1223 757 731 979 2 AOI211X2_HS $T=99820 38640 1 0 $X=99640 $Y=34195
X6340 VSS: 2 VSS: 1225 1224 1041 2 CLKAND2X2 $T=101660 38640 0 0 $X=101480 $Y=38375
X6346 VSS: 2 VSS: 1223 1221 1228 1226 1227 2 OAI22X1 $T=100280 46920 1 0 $X=100100 $Y=42475
X6352 VSS: 2 VSS: 1491 1490 1222 709 2 NAND3X2_HS $T=113620 46920 1 0 $X=113440 $Y=42475
X6358 VSS: 2 VSS: 981 287 275 2 NAND2X1_HS $T=100280 55200 1 0 $X=100100 $Y=50755
X6363 VSS: 2 VSS: 987 981 1216 1488 1492 2 NAND4X1 $T=117300 55200 0 180 $X=114360 $Y=50755
X6365 VSS: 2 VSS: 982 287 299 2 NAND2X1 $T=99820 55200 0 0 $X=99640 $Y=54935
X6368 VSS: 2 VSS: 287 1229 2 BUFX4_HS $T=109940 55200 1 180 $X=106080 $Y=54935
X6375 VSS: 2 VSS: 1230 1218 1216 982 988 2 NAND4X2_HS $T=110400 63480 1 0 $X=110220 $Y=59035
X6383 VSS: 2 VSS: 1231 1230 2 CLKINVX2_HS $T=110860 71760 1 0 $X=110680 $Y=67315
X6385 VSS: 2 VSS: 1226 735 2 BUFX2 $T=99360 71760 0 0 $X=99180 $Y=71495
X6387 VSS: 2 VSS: 1232 1227 2 INVX2 $T=105340 71760 0 0 $X=105160 $Y=71495
X6392 VSS: 2 VSS: 1233 1234 733 2 CLKAND2X2 $T=103500 80040 1 0 $X=103320 $Y=75595
X6395 VSS: 2 VSS: 1234 1235 1232 2 NAND2X1_HS $T=110860 80040 0 180 $X=108380 $Y=75595
X6398 VSS: 2 VSS: 1235 1221 2 INVX2 $T=115000 80040 0 180 $X=113440 $Y=75595
X6405 VSS: 2 VSS: 1238 738 991 1237 720 2 AOI211X2_HS $T=108100 88320 0 180 $X=102400 $Y=83875
X6412 VSS: 2 VSS: 1500 1238 556 1239 2 AOI21X2_HS $T=111320 88320 0 0 $X=111140 $Y=88055
X6416 VSS: 2 VSS: 1242 994 1241 990 2 NAND3X1 $T=108100 96600 1 0 $X=107920 $Y=92155
X6420 VSS: 2 VSS: 1245 977 1244 2 NAND2X1 $T=104880 96600 0 0 $X=104700 $Y=96335
X6422 VSS: 2 VSS: 1241 1244 977 556 1239 2 AOI22X1 $T=110400 96600 0 0 $X=110220 $Y=96335
X6427 VSS: 2 VSS: 977 393 2 BUFX2 $T=109480 104880 1 0 $X=109300 $Y=100435
X6432 VSS: 2 VSS: 1248 1227 2 INVX2 $T=103040 104880 0 0 $X=102860 $Y=104615
X6436 VSS: 2 VSS: 1247 1243 1248 2 NAND2X1_HS $T=111780 104880 1 180 $X=109300 $Y=104615
X6439 VSS: 2 VSS: 1227 70 2 BUFX2_HS $T=100280 113160 1 0 $X=100100 $Y=108715
X6442 VSS: 2 VSS: 1004 1231 2 CLKINVX1 $T=109940 113160 0 180 $X=108380 $Y=108715
X6448 VSS: 2 VSS: 1252 1007 1003 2 NOR2X2_HS $T=107640 113160 1 180 $X=104240 $Y=112895
X6452 VSS: 2 VSS: 1249 1250 515 573 1251 2 AOI22X1_HS $T=110860 113160 0 0 $X=110680 $Y=112895
X6456 VSS: 2 VSS: 1253 533 2 CLKBUFX2_HS $T=105340 121440 1 0 $X=105160 $Y=116995
X6459 VSS: 2 VSS: 1255 1008 1254 2 CLKAND2X2 $T=111320 121440 1 0 $X=111140 $Y=116995
X6476 VSS: 2 VSS: 1258 1257 1018 2 NOR2X2_HS $T=111320 138000 0 180 $X=107920 $Y=133555
X6482 VSS: 2 VSS: 64 998 991 1231 2 OAI21X1 $T=111320 138000 0 0 $X=111140 $Y=137735
X6485 VSS: 2 VSS: 762 1228 2 CLKBUFX2 $T=102120 146280 0 180 $X=99640 $Y=141835
X6490 VSS: 2 VSS: 1259 799 1231 1285 1236 2 OAI22X1 $T=116380 146280 0 180 $X=113440 $Y=141835
X6491 VSS: 2 VSS: 1261 761 1260 65 788 2 OAI211X1_HS $T=99360 146280 0 0 $X=99180 $Y=146015
X6495 VSS: 2 VSS: 802 512 2 INVX8_HS $T=115460 146280 1 180 $X=110220 $Y=146015
X6497 VSS: 2 VSS: 760 1262 748 989 1256 2 AOI22X1_HS $T=104420 154560 0 180 $X=101020 $Y=150115
X6505 VSS: 2 VSS: 1256 548 2 BUFX2_HS $T=108560 154560 0 0 $X=108380 $Y=154295
X6511 VSS: 2 VSS: 1263 515 2 CLKINVX1 $T=109940 162840 1 0 $X=109760 $Y=158395
X6514 VSS: 2 VSS: 1265 162 748 73 2 AOI21X2_HS $T=100280 162840 0 0 $X=100100 $Y=162575
X6518 VSS: 2 VSS: 1266 512 2 CLKBUFX2 $T=109940 162840 0 0 $X=109760 $Y=162575
X6520 VSS: 2 VSS: 1262 578 2 BUFX2_HS $T=99820 171120 1 0 $X=99640 $Y=166675
X6522 VSS: 2 VSS: 1267 1264 573 976 2 AOI21X2_HS $T=110860 171120 0 180 $X=106080 $Y=166675
X6527 VSS: 2 VSS: 1269 1228 2 INVX2_HS $T=103960 171120 0 0 $X=103780 $Y=170855
X6529 VSS: 2 VSS: 1268 1267 2 CLKINVX1 $T=109940 171120 0 0 $X=109760 $Y=170855
X6534 VSS: 2 VSS: 1270 516 1025 1269 2 AOI21X1_HS $T=105800 179400 1 0 $X=105620 $Y=174955
X6541 VSS: 2 VSS: 1271 753 1267 72 1270 2 OAI211X1_HS $T=106260 179400 0 0 $X=106080 $Y=179135
X6546 VSS: 2 VSS: 1272 1271 1265 1026 2 NAND3X2_HS $T=105800 187680 1 0 $X=105620 $Y=183235
X6550 VSS: 2 VSS: 43 71 559 1236 548 2 OAI22X2_HS $T=106720 187680 1 180 $X=101020 $Y=187415
X6558 VSS: 2 VSS: 1274 1231 548 802 71 2 OAI22X1_HS $T=111320 195960 1 0 $X=111140 $Y=191515
X6563 VSS: 2 VSS: 1034 515 2 CLKINVX1 $T=108560 195960 1 180 $X=107000 $Y=195695
X6569 VSS: 2 VSS: 1275 1064 1228 2 NOR2X2_HS $T=109480 204240 1 0 $X=109300 $Y=199795
X6573 VSS: 2 VSS: 1277 621 2 INVX2 $T=103960 204240 0 0 $X=103780 $Y=203975
X6576 VSS: 2 VSS: 1278 1277 777 2 NAND2X2_HS $T=107640 204240 0 0 $X=107460 $Y=203975
X6580 VSS: 2 VSS: 1279 621 2 INVX4 $T=103960 212520 0 180 $X=101480 $Y=208075
X6583 VSS: 2 VSS: 1280 1221 800 72 802 2 OAI22X2_HS $T=114080 212520 0 180 $X=108380 $Y=208075
X6587 VSS: 2 VSS: 1281 1279 1043 2 NAND2X1_HS $T=104420 212520 0 0 $X=104240 $Y=212255
X6593 VSS: 2 VSS: 998 1282 2 CLKBUFX4 $T=103960 220800 1 0 $X=103780 $Y=216355
X6595 VSS: 2 VSS: 1283 1280 1275 2 OR2X1_HS $T=110400 220800 1 0 $X=110220 $Y=216355
X6600 VSS: 2 VSS: 42 799 1231 1284 801 2 OAI22X2_HS $T=114540 220800 1 180 $X=108840 $Y=220535
X6606 VSS: 2 VSS: 40 800 1285 533 802 2 OAI22X2_HS $T=108560 229080 1 0 $X=108380 $Y=224635
X6610 VSS: 2 VSS: 1287 621 1286 786 39 2 OAI211X1_HS $T=106260 229080 0 0 $X=106080 $Y=228815
X6612 VSS: 2 VSS: 1048 784 2 BUFX2 $T=104880 237360 0 180 $X=102400 $Y=232915
X6614 VSS: 2 VSS: 1254 592 775 2 OR2X1 $T=108560 237360 1 0 $X=108380 $Y=232915
X6620 VSS: 2 VSS: 1288 1052 775 2 OR2X1 $T=108100 237360 0 0 $X=107920 $Y=237095
X6621 VSS: 2 VSS: 1289 1054 775 2 OR2X1 $T=110400 237360 0 0 $X=110220 $Y=237095
X6625 VSS: 2 VSS: 1290 356 2 BUFX2_HS $T=103500 245640 1 0 $X=103320 $Y=241195
X6629 VSS: 2 VSS: 1291 621 1054 2 OR2X1_HS $T=112240 245640 1 0 $X=112060 $Y=241195
X6639 VSS: 2 VSS: 1293 71 802 1290 519 2 OAI22X1_HS $T=113620 253920 0 180 $X=110220 $Y=249475
X6643 VSS: 2 VSS: 1294 1048 399 1290 519 2 OAI22X1 $T=103040 253920 0 0 $X=102860 $Y=253655
X6648 VSS: 2 VSS: 1295 1023 2 BUFX2 $T=112700 253920 0 0 $X=112520 $Y=253655
X6651 VSS: 2 VSS: 1296 1051 1297 2 AND2X1_HS $T=102120 262200 1 0 $X=101940 $Y=257755
X6655 VSS: 2 VSS: 1298 1272 1296 2 NAND2X2_HS $T=111320 262200 1 0 $X=111140 $Y=257755
X6660 VSS: 2 VSS: 1064 799 2 CLKBUFX2_HS $T=105800 262200 0 0 $X=105620 $Y=261935
X6663 VSS: 2 VSS: 1301 1300 2 BUFX4_HS $T=99820 270480 1 0 $X=99640 $Y=266035
X6668 VSS: 2 VSS: 372 1303 2 BUFX4_HS $T=114080 270480 0 180 $X=110220 $Y=266035
X6672 VSS: 2 VSS: 1282 1304 2 BUFX8_HS $T=111780 270480 1 180 $X=106080 $Y=270215
X6675 VSS: 2 VSS: 516 1282 2 INVX8_HS $T=104880 278760 1 0 $X=104700 $Y=274315
X6680 VSS: 2 VSS: 1062 1306 840 2 NOR2X2_HS $T=106720 278760 1 180 $X=103320 $Y=278495
X6684 VSS: 2 VSS: 1304 1306 1305 2 NAND2X1_HS $T=112240 278760 1 180 $X=109760 $Y=278495
X6689 VSS: 2 VSS: 1307 840 1306 2 NAND2X2_HS $T=104880 287040 0 180 $X=101480 $Y=282595
X6692 VSS: 2 VSS: 1305 840 2 CLKINVX1 $T=109020 287040 1 0 $X=108840 $Y=282595
X6697 VSS: 2 VSS: 1039 82 55 2 NAND2X2 $T=106720 287040 1 180 $X=104240 $Y=286775
X6703 VSS: 2 VSS: 1286 1088 82 1310 1311 2 OAI211X1_HS $T=104420 295320 1 0 $X=104240 $Y=290875
X6707 VSS: 2 VSS: 1315 1303 1309 2 NAND2X2 $T=114080 295320 1 0 $X=113900 $Y=290875
X6711 VSS: 2 VSS: 1311 1088 1310 2 NAND2X1_HS $T=104880 295320 0 0 $X=104700 $Y=295055
X6714 VSS: 2 VSS: 1309 635 2 CLKBUFX2 $T=111320 295320 0 0 $X=111140 $Y=295055
X6719 VSS: 2 VSS: 1297 82 50 2 NAND2X4_HS $T=107180 303600 0 180 $X=101940 $Y=299155
X6722 VSS: 2 VSS: 1312 1309 1303 2 NOR2X2 $T=112700 303600 1 0 $X=112520 $Y=299155
X6725 VSS: 2 VSS: 1310 1313 1314 52 2 AOI21X1_HS $T=105340 303600 0 0 $X=105160 $Y=303335
X6728 VSS: 2 VSS: 1316 1312 2 CLKBUFX2 $T=110400 303600 0 0 $X=110220 $Y=303335
X6729 VSS: 2 VSS: 1321 1312 1315 1341 2 OAI21X2_HS $T=112700 303600 0 0 $X=112520 $Y=303335
X6732 VSS: 2 VSS: 1319 1317 1318 1077 2 AOI21X2_HS $T=106260 311880 1 0 $X=106080 $Y=307435
X6737 VSS: 2 VSS: 1320 1318 1080 2 NAND2X2_HS $T=103960 311880 1 180 $X=100560 $Y=311615
X6741 VSS: 2 VSS: 1314 1077 2 CLKBUFX2 $T=109480 311880 1 180 $X=107000 $Y=311615
X6743 VSS: 2 VSS: 1322 1321 2 INVX1 $T=114540 311880 1 180 $X=112980 $Y=311615
X6745 VSS: 2 VSS: 1323 624 2 INVX2 $T=101660 320160 1 0 $X=101480 $Y=315715
X6747 VSS: 2 VSS: 1313 1080 2 CLKBUFX2 $T=103960 320160 1 0 $X=103780 $Y=315715
X6750 VSS: 2 VSS: 1325 1323 807 621 1324 2 OAI211X2_HS $T=108560 320160 1 0 $X=108380 $Y=315715
X6752 VSS: 2 VSS: 1318 1085 1107 2 NOR2X4_HS $T=103960 320160 1 180 $X=98720 $Y=319895
X6754 VSS: 2 VSS: 58 1315 1326 2 NAND2X1 $T=109480 320160 1 180 $X=107460 $Y=319895
X6757 VSS: 2 VSS: 1326 1316 2 CLKINVX1 $T=112240 320160 0 0 $X=112060 $Y=319895
X6761 VSS: 2 VSS: 1328 1085 2 CLKBUFX2 $T=102580 328440 0 180 $X=100100 $Y=323995
X6765 VSS: 2 VSS: 1329 1327 2 CLKINVX1 $T=111320 328440 1 0 $X=111140 $Y=323995
X6769 VSS: 2 VSS: 1089 1328 2 CLKINVX1 $T=100740 328440 1 180 $X=99180 $Y=328175
X6773 VSS: 2 VSS: 1074 1331 1332 2 XNOR2X1_HS $T=108100 328440 1 180 $X=103780 $Y=328175
X6776 VSS: 2 VSS: 1332 1330 1329 2 NAND2X1 $T=114540 328440 1 180 $X=112520 $Y=328175
X6781 VSS: 2 VSS: 1335 1322 2 CLKBUFX2 $T=106720 336720 0 180 $X=104240 $Y=332275
X6783 VSS: 2 VSS: 1331 1322 1334 1333 2 OAI21X1_HS $T=113160 336720 0 180 $X=110220 $Y=332275
X6786 VSS: 2 VSS: 1260 1335 82 1337 1336 2 OAI211X1_HS $T=104420 336720 1 180 $X=101020 $Y=336455
X6790 VSS: 2 VSS: 1338 1333 2 CLKINVX1 $T=110860 336720 1 180 $X=109300 $Y=336455
X6793 VSS: 2 VSS: 1324 82 1614 2 NAND2X2_HS $T=116840 336720 1 180 $X=113440 $Y=336455
X6797 VSS: 2 VSS: 1336 1335 1337 2 NAND2X1 $T=103040 345000 1 0 $X=102860 $Y=340555
X6800 VSS: 2 VSS: 1337 1334 1338 2 NAND2X1 $T=110860 345000 0 180 $X=108840 $Y=340555
X6802 VSS: 2 VSS: 1604 635 1616 1617 2 OAI21X2_HS $T=114540 345000 1 0 $X=114360 $Y=340555
X6805 VSS: 2 VSS: 1103 1339 2 BUFX2_HS $T=106260 345000 1 180 $X=103320 $Y=344735
X6807 VSS: 2 VSS: 1339 1306 2 CLKINVX2_HS $T=107180 345000 0 0 $X=107000 $Y=344735
X6809 VSS: 2 VSS: 1340 627 1339 2 NOR2X2_HS $T=115000 345000 1 180 $X=111600 $Y=344735
X6811 VSS: 2 VSS: 57 1342 2 CLKBUFX2 $T=99360 353280 1 0 $X=99180 $Y=348835
X6813 VSS: 2 VSS: 1341 1342 2 INVX2_HS $T=105340 353280 1 0 $X=105160 $Y=348835
X6817 VSS: 2 VSS: 1616 627 1343 1339 635 2 OAI211X1_HS $T=112700 353280 1 0 $X=112520 $Y=348835
X6821 VSS: 2 VSS: 1110 426 2 BUFX2_HS $T=104880 353280 1 180 $X=101940 $Y=353015
X6824 VSS: 2 VSS: 1344 635 2 INVX2 $T=110860 353280 1 180 $X=109300 $Y=353015
X6826 VSS: 2 VSS: 1343 1347 2 CLKINVX2 $T=115920 353280 1 180 $X=114360 $Y=353015
X6829 VSS: 2 VSS: 1342 1348 1346 2 NAND2X2_HS $T=103500 361560 0 180 $X=100100 $Y=357115
X6831 VSS: 2 VSS: 1346 1344 1345 2 NAND2X2_HS $T=108560 361560 0 180 $X=105160 $Y=357115
X6834 VSS: 2 VSS: 1347 847 639 2 NOR2X2_HS $T=111320 361560 1 0 $X=111140 $Y=357115
X6838 VSS: 2 VSS: 1348 1350 1351 2 NAND2X2_HS $T=105800 361560 1 180 $X=102400 $Y=361295
X6841 VSS: 2 VSS: 1345 1349 1351 2 NAND2X2_HS $T=108560 361560 0 0 $X=108380 $Y=361295
X6843 VSS: 2 VSS: 1351 1363 303 2 NAND2X4_HS $T=118680 361560 1 180 $X=113440 $Y=361295
X6846 VSS: 2 VSS: 1350 1352 1353 2 NOR2X1_HS $T=105800 369840 1 0 $X=105620 $Y=365395
X6848 VSS: 2 VSS: 1352 635 2 INVX2_HS $T=109940 369840 1 0 $X=109760 $Y=365395
X6853 VSS: 2 VSS: 1353 1349 2 INVX2 $T=102580 369840 0 0 $X=102400 $Y=369575
X6857 VSS: 2 VSS: 1354 1355 1356 2 NOR2X1_HS $T=109020 369840 0 0 $X=108840 $Y=369575
X6862 VSS: 2 VSS: 1356 1357 448 2 XOR2X1_HS $T=104880 378120 1 0 $X=104700 $Y=373675
X6864 VSS: 2 VSS: 1358 639 2 CLKINVX2 $T=114080 378120 0 180 $X=112520 $Y=373675
X6867 VSS: 2 VSS: 1120 635 2 INVX2_HS $T=103960 378120 1 180 $X=101480 $Y=377855
X6871 VSS: 2 VSS: 1349 1359 1358 2 NAND2X1_HS $T=109480 378120 1 180 $X=107000 $Y=377855
X6874 VSS: 2 VSS: 1639 addr_i[12] addr_i[13] 1360 2 OR3X1 $T=114080 378120 0 0 $X=113900 $Y=377855
X6878 VSS: 2 VSS: 1359 1361 2 INVX1_HS $T=110400 386400 0 180 $X=108380 $Y=381955
X6881 VSS: 2 VSS: 862 1362 1365 2 NOR2X2_HS $T=98900 386400 0 0 $X=98720 $Y=386135
X6885 VSS: 2 VSS: 1362 1364 2 CLKINVX2 $T=107180 386400 0 0 $X=107000 $Y=386135
X6888 VSS: 2 VSS: 230 1365 1364 2 CLKAND2X2 $T=103960 394680 0 180 $X=101480 $Y=390235
X6893 VSS: 2 VSS: 1369 1647 1364 2 AND2X1 $T=113620 394680 1 0 $X=113440 $Y=390235
X6897 VSS: 2 VSS: 1363 1127 2 CLKBUFX4 $T=104420 394680 0 0 $X=104240 $Y=394415
X6900 VSS: 2 VSS: 1364 97 2 BUFX8 $T=113620 394680 1 180 $X=108380 $Y=394415
X6903 VSS: 2 VSS: 1365 1368 1366 97 2 NAND3X2_HS $T=105340 402960 0 180 $X=100560 $Y=398515
X6905 VSS: 2 VSS: 1371 1370 424 1367 2 AOI21X1 $T=109020 402960 1 0 $X=108840 $Y=398515
X6909 VSS: 2 VSS: 1366 1370 1369 2 AND2X1 $T=114540 402960 1 0 $X=114360 $Y=398515
X6911 VSS: 2 VSS: 1367 1369 1372 1131 2 NAND3X1 $T=105800 402960 1 180 $X=103320 $Y=402695
X6914 VSS: 2 VSS: 1374 1373 1369 2 NAND2X1 $T=113160 402960 1 180 $X=111140 $Y=402695
X6919 VSS: 2 VSS: 1377 1368 2 INVX1 $T=105800 411240 0 180 $X=104240 $Y=406795
X6922 VSS: 2 VSS: 1368 1376 2 INVX1 $T=109940 411240 0 180 $X=108380 $Y=406795
X6925 VSS: 2 VSS: 1373 1375 2 CLKBUFX2 $T=115000 411240 0 180 $X=112520 $Y=406795
X6926 VSS: 2 VSS: 1378 871 2 CLKINVX1 $T=98900 411240 0 0 $X=98720 $Y=410975
X6931 VSS: 2 VSS: 1376 1375 2 CLKBUFX2 $T=111320 411240 1 180 $X=108840 $Y=410975
X6934 VSS: 2 VSS: 1381 1135 2 BUFX2 $T=99820 419520 1 0 $X=99640 $Y=415075
X6937 VSS: 2 VSS: 693 1380 2 INVX8_HS $T=108560 419520 0 180 $X=103320 $Y=415075
X6939 VSS: 2 VSS: 1379 880 2 CLKINVX1 $T=110400 419520 1 0 $X=110220 $Y=415075
X6945 VSS: 2 VSS: 1131 880 2 BUFX2_HS $T=103040 419520 0 0 $X=102860 $Y=419255
X6948 VSS: 2 VSS: 689 1383 2 INVX4_HS $T=111320 419520 1 180 $X=107920 $Y=419255
X6950 VSS: 2 VSS: 1384 1664 2 INVX4_HS $T=116380 419520 1 180 $X=112980 $Y=419255
X6952 VSS: 2 VSS: 1137 1385 1384 2 NOR2X2_HS $T=102580 427800 0 180 $X=99180 $Y=423355
X6955 VSS: 2 VSS: 1386 689 693 2 NOR2X4_HS $T=111780 427800 0 180 $X=106540 $Y=423355
X6958 VSS: 2 VSS: 1387 1385 1384 2 NOR2X2_HS $T=102580 427800 0 0 $X=102400 $Y=427535
X6962 VSS: 2 VSS: 1390 1388 1138 1386 2 NAND3X2_HS $T=111780 427800 0 0 $X=111600 $Y=427535
X6964 VSS: 2 VSS: 1389 1391 2 CLKINVX1_HS $T=106260 436080 0 180 $X=103320 $Y=431635
X6967 VSS: 2 VSS: 1140 1390 2 BUFX2 $T=110860 436080 0 180 $X=108380 $Y=431635
X6972 VSS: 2 VSS: 1391 1141 1387 1143 2 NAND3X2_HS $T=104420 436080 0 0 $X=104240 $Y=435815
X6976 VSS: 2 VSS: 1355 1392 1393 2 NAND2X1_HS $T=101660 444360 1 0 $X=101480 $Y=439915
X6982 VSS: 2 VSS: 1143 1670 2 BUFX2_HS $T=117300 444360 0 180 $X=114360 $Y=439915
X6987 VSS: 2 VSS: 1674 1672 1673 1395 1394 2 NAND4X4_HS $T=120060 444360 1 180 $X=111140 $Y=444095
X6988 VSS: 2 VSS: 1392 1145 1396 2 NAND2X2_HS $T=98900 452640 1 0 $X=98720 $Y=448195
X6991 VSS: 2 VSS: 1145 1397 2 BUFX8_HS $T=104880 452640 1 0 $X=104700 $Y=448195
X6997 VSS: 2 VSS: 1397 1400 1398 2 NAND2X1_HS $T=107180 452640 1 180 $X=104700 $Y=452375
X7001 VSS: 2 VSS: 1398 1399 1674 2 NOR2X2_HS $T=113160 452640 0 0 $X=112980 $Y=452375
X7010 VSS: 2 VSS: 1403 1681 1402 1401 2 NAND3X4_HS $T=117760 460920 1 180 $X=110680 $Y=460655
X7011 VSS: 2 VSS: 1069 1405 1404 2 NAND2X4_HS $T=104420 469200 0 180 $X=99180 $Y=464755
X7013 VSS: 2 VSS: 1405 1407 1406 2 NOR2X2_HS $T=108100 469200 1 0 $X=107920 $Y=464755
X7016 VSS: 2 VSS: 1404 1684 1403 2 NOR2X4_HS $T=117760 469200 0 180 $X=112520 $Y=464755
X7021 VSS: 2 VSS: 1411 1408 1152 1410 1409 2 NAND4X1_HS $T=109940 469200 1 180 $X=106540 $Y=468935
X7028 VSS: 2 VSS: 1400 1689 1414 2 NOR2X2_HS $T=116380 477480 0 180 $X=112980 $Y=473035
X7034 VSS: 2 VSS: 1159 1691 1685 1688 1692 2 AOI22X1_HS $T=114080 477480 0 0 $X=113900 $Y=477215
X7039 VSS: 2 VSS: 1407 1417 1416 1162 1415 2 NAND4X1_HS $T=108100 485760 1 0 $X=107920 $Y=481315
X7045 VSS: 2 VSS: 1414 1419 1165 1420 1418 2 NAND4X1_HS $T=112240 485760 1 180 $X=108840 $Y=485495
X7050 VSS: 2 VSS: 1420 1422 1421 1413 1412 2 AOI22X1_HS $T=112240 494040 0 180 $X=108840 $Y=489595
X7054 VSS: 2 VSS: 1417 1167 1423 1424 1166 2 AOI22X1 $T=107180 494040 0 0 $X=107000 $Y=493775
X7061 VSS: 2 VSS: 1415 1170 1421 1422 1171 2 AOI22X1 $T=110860 502320 1 0 $X=110680 $Y=497875
X7067 VSS: 2 VSS: 1419 1424 1423 1426 1425 2 AOI22X1_HS $T=112700 502320 1 180 $X=109300 $Y=502055
X7072 VSS: 2 VSS: 1409 1426 1169 1168 1425 2 AOI22X1_HS $T=104420 510600 1 0 $X=104240 $Y=506155
X7077 VSS: 2 VSS: 1429 1427 1428 918 919 2 AOI22X2_HS $T=100280 510600 0 0 $X=100100 $Y=510335
X7086 VSS: 2 VSS: 1399 1431 1699 1430 1707 2 NAND4X2_HS $T=112700 518880 1 0 $X=112520 $Y=514435
X7088 VSS: 2 VSS: 1432 929 1427 1428 928 2 AOI22X1_HS $T=101200 518880 0 0 $X=101020 $Y=518615
X7093 VSS: 2 VSS: 1433 935 1435 1434 934 2 AOI22X1 $T=102580 527160 1 0 $X=102400 $Y=522715
X7100 VSS: 2 VSS: 1436 925 1434 1435 926 2 AOI22X2 $T=109940 527160 1 180 $X=105160 $Y=526895
X7104 VSS: 2 VSS: 1439 704 1437 1438 705 2 AOI22X2_HS $T=106260 535440 0 180 $X=100560 $Y=530995
X7108 VSS: 2 VSS: 1441 1436 1439 1440 1429 2 NAND4X2_HS $T=105800 535440 1 180 $X=100100 $Y=535175
X7113 VSS: 2 VSS: 1442 939 1438 1437 940 2 AOI22X2_HS $T=103500 543720 1 0 $X=103320 $Y=539275
X7117 VSS: 2 VSS: 1444 1433 1442 1443 1432 2 NAND4X1_HS $T=100280 543720 0 0 $X=100100 $Y=543455
X7124 VSS: 2 VSS: 1445 1182 1183 1426 1425 2 AOI22X1_HS $T=103960 552000 1 0 $X=103780 $Y=547555
X7133 VSS: 2 VSS: 1446 1425 1721 1720 1426 2 AOI22X2_HS $T=119140 552000 1 180 $X=113440 $Y=551735
X7136 VSS: 2 VSS: 419 1447 2 BUFX8_HS $T=102580 560280 1 0 $X=102400 $Y=555835
X7140 VSS: 2 VSS: 1448 1166 1721 1720 1167 2 AOI22X2 $T=119140 560280 0 180 $X=114360 $Y=555835
X7143 VSS: 2 VSS: 1447 1453 1454 2 NAND2X2_HS $T=107180 560280 1 180 $X=103780 $Y=560015
X7145 VSS: 2 VSS: 1453 1449 1451 2 NOR2X2_HS $T=108100 560280 0 0 $X=107920 $Y=560015
X7147 VSS: 2 VSS: 1449 1448 1724 1452 1455 2 NAND4X2_HS $T=113160 560280 0 0 $X=112980 $Y=560015
X7157 VSS: 2 VSS: 1459 1457 1412 1413 1458 2 AOI22X1_HS $T=115000 568560 1 180 $X=111600 $Y=568295
X7161 VSS: 2 VSS: 1456 1171 1457 1458 1170 2 AOI22X2_HS $T=114080 576840 0 180 $X=108380 $Y=572395
X7163 VSS: 2 VSS: 1097 1461 2 BUFX8_HS $T=100740 576840 0 0 $X=100560 $Y=576575
X7168 VSS: 2 VSS: 1460 1441 1462 2 NOR2X2_HS $T=104880 585120 0 180 $X=101480 $Y=580675
X7173 VSS: 2 VSS: 1199 1691 1733 1463 1692 2 AOI22X2_HS $T=113620 585120 1 0 $X=113440 $Y=580675
X7174 VSS: 2 VSS: 1195 1464 1467 2 NOR2X1_HS $T=103040 585120 1 180 $X=100560 $Y=584855
X7177 VSS: 2 VSS: 1468 1465 1466 1413 1412 2 AOI22X1_HS $T=113620 585120 1 180 $X=110220 $Y=584855
X7181 VSS: 2 VSS: 1464 1468 1202 1469 1446 2 NAND4X1_HS $T=107180 593400 0 180 $X=103780 $Y=588955
X7188 VSS: 2 VSS: 1452 1171 1465 1466 1170 2 AOI22X2_HS $T=115460 593400 1 180 $X=109760 $Y=593135
X7191 VSS: 2 VSS: 1470 1204 1205 1413 1412 2 AOI22X1_HS $T=105800 601680 1 0 $X=105620 $Y=597235
X7196 VSS: 2 VSS: 1472 1470 1471 1445 1203 2 NAND4X2_HS $T=109480 601680 1 180 $X=103780 $Y=601415
X7204 VSS: 2 VSS: 1451 1734 1735 2 NAND2X4_HS $T=119600 609960 0 180 $X=114360 $Y=605515
X7206 VSS: 2 VSS: 1357 1474 1473 2 NAND2X4_HS $T=109480 609960 1 180 $X=104240 $Y=609695
X7208 VSS: 2 VSS: 1474 1476 1472 2 NOR2X4_HS $T=115000 609960 1 180 $X=109760 $Y=609695
X7211 VSS: 2 VSS: 1477 1209 1206 2 NAND2X1 $T=103500 618240 1 0 $X=103320 $Y=613795
X7222 VSS: 2 VSS: 1478 1481 2 INVX4_HS $T=98900 626520 0 0 $X=98720 $Y=626255
X7228 VSS: 2 VSS: 1481 1483 1482 2 NAND2X2_HS $T=108560 634800 0 180 $X=105160 $Y=630355
X7254 VSS: 2 VSS: 1215 1485 2 CLKBUFX2 $T=117300 22080 0 180 $X=114820 $Y=17635
X7266 VSS: 2 VSS: 1489 1487 1486 1217 1488 2 NAND4X2_HS $T=125120 22080 0 0 $X=124940 $Y=21815
X7271 VSS: 2 VSS: 1250 1489 2 BUFX8_HS $T=125580 30360 1 0 $X=125400 $Y=25915
X7279 VSS: 2 VSS: 1217 485 299 2 NAND2X2 $T=122360 30360 0 0 $X=122180 $Y=30095
X7291 VSS: 2 VSS: 1485 274 270 2 NAND2X2_HS $T=120060 38640 1 180 $X=116660 $Y=38375
X7295 VSS: 2 VSS: 1488 274 276 2 NAND2X4 $T=126040 38640 0 0 $X=125860 $Y=38375
X7297 VSS: 2 VSS: 1228 1491 2 INVX4_HS $T=118220 46920 1 0 $X=118040 $Y=42475
X7307 VSS: 2 VSS: 1490 1492 1485 2 CLKAND2X2 $T=118680 46920 1 180 $X=116200 $Y=46655
X7316 VSS: 2 VSS: 976 1751 2 BUFX8_HS $T=132940 55200 0 180 $X=127240 $Y=50755
X7321 VSS: 2 VSS: 1492 284 299 2 NAND2X1_HS $T=115920 55200 0 0 $X=115740 $Y=54935
X7324 VSS: 2 VSS: 721 1493 145 317 1494 2 OAI22X1 $T=126500 55200 1 180 $X=123560 $Y=54935
X7330 VSS: 2 VSS: 726 1494 145 317 496 2 OAI22X1 $T=126500 63480 0 180 $X=123560 $Y=59035
X7339 VSS: 2 VSS: 1495 496 493 299 276 2 AOI22X2_HS $T=121440 63480 0 0 $X=121260 $Y=63215
X7344 VSS: 2 VSS: 1496 275 1494 1493 270 2 AOI22X2_HS $T=127880 71760 0 180 $X=122180 $Y=67315
X7352 VSS: 2 VSS: 1497 1496 1495 2 NAND2X2_HS $T=126040 71760 1 180 $X=122640 $Y=71495
X7357 VSS: 2 VSS: 1023 1497 2 INVX4_HS $T=122820 80040 0 180 $X=119420 $Y=75595
X7361 VSS: 2 VSS: 1221 1498 2 BUFX4_HS $T=129720 80040 0 180 $X=125860 $Y=75595
X7366 VSS: 2 VSS: 1499 1493 276 299 1494 2 AOI22X2_HS $T=117760 80040 0 0 $X=117580 $Y=79775
X7371 VSS: 2 VSS: 600 1499 2 BUFX8_HS $T=117300 88320 1 0 $X=117120 $Y=83875
X7374 VSS: 2 VSS: 1776 1494 271 2 NAND2X1 $T=130180 88320 1 0 $X=130000 $Y=83875
X7383 VSS: 2 VSS: 1502 1501 2 BUFX4_HS $T=131100 88320 1 180 $X=127240 $Y=88055
X7384 VSS: 2 VSS: 1501 1778 1773 1776 2 NAND3X1_HS $T=131100 88320 0 0 $X=130920 $Y=88055
X7386 VSS: 2 VSS: 1243 600 2 INVX2 $T=118220 96600 0 180 $X=116660 $Y=92155
X7389 VSS: 2 VSS: 1239 1502 2 BUFX2 $T=126040 96600 0 180 $X=123560 $Y=92155
X7392 VSS: 2 VSS: 1778 496 276 2 NAND2X1 $T=130180 96600 1 0 $X=130000 $Y=92155
X7396 VSS: 2 VSS: 1244 1250 2 CLKBUFX2 $T=119140 96600 1 180 $X=116660 $Y=96335
X7398 VSS: 2 VSS: 1503 1237 2 CLKINVX1 $T=122820 96600 0 0 $X=122640 $Y=96335
X7401 VSS: 2 VSS: 276 206 2 BUFX16_HS $T=136620 96600 1 180 $X=126320 $Y=96335
X7402 VSS: 2 VSS: 1504 992 1505 2 NAND2X1_HS $T=115000 104880 1 0 $X=114820 $Y=100435
X7405 VSS: 2 VSS: 1506 1504 1246 2 NOR2X4_HS $T=125120 104880 0 180 $X=119880 $Y=100435
X7408 VSS: 2 VSS: 1285 1502 2 INVX8_HS $T=127880 104880 1 0 $X=127700 $Y=100435
X7413 VSS: 2 VSS: 1505 1507 2 CLKINVX1 $T=118680 104880 1 180 $X=117120 $Y=104615
X7416 VSS: 2 VSS: 1251 1502 2 CLKBUFX2 $T=128340 104880 1 180 $X=125860 $Y=104615
X7419 VSS: 2 VSS: 1507 1236 1231 1285 70 2 OAI22X1 $T=116380 113160 1 0 $X=116200 $Y=108715
X7429 VSS: 2 VSS: 1510 70 2 BUFX2 $T=117300 113160 0 0 $X=117120 $Y=112895
X7432 VSS: 2 VSS: 1509 1295 1510 2 NOR2X1 $T=126960 113160 0 0 $X=126780 $Y=112895
X7433 VSS: 2 VSS: 62 1249 2 INVX2_HS $T=128800 113160 0 0 $X=128620 $Y=112895
X7437 VSS: 2 VSS: 1511 71 2 BUFX2 $T=116840 121440 1 0 $X=116660 $Y=116995
X7441 VSS: 2 VSS: 1513 1512 1503 2 NAND2X1_HS $T=122360 121440 1 0 $X=122180 $Y=116995
X7448 VSS: 2 VSS: 1515 1253 1256 1511 70 2 OAI22X1 $T=116380 121440 0 0 $X=116200 $Y=121175
X7454 VSS: 2 VSS: 1802 1514 62 2 NAND2X1_HS $T=129720 121440 0 0 $X=129540 $Y=121175
X7456 VSS: 2 VSS: 1516 1513 1517 2 AND2X1_HS $T=119140 129720 1 0 $X=118960 $Y=125275
X7466 VSS: 2 VSS: 1517 1518 1515 1250 1259 2 AOI211X1 $T=121440 129720 1 180 $X=118500 $Y=129455
X7475 VSS: 2 VSS: 1519 1288 1258 2 AND2X1_HS $T=124660 138000 1 0 $X=124480 $Y=133555
X7484 VSS: 2 VSS: 1514 770 2 INVX2 $T=126500 138000 0 0 $X=126320 $Y=137735
X7495 VSS: 2 VSS: 1518 802 2 CLKINVX1 $T=117760 146280 0 0 $X=117580 $Y=146015
X7498 VSS: 2 VSS: 1284 1250 2 CLKINVX4_HS $T=123280 146280 0 0 $X=123100 $Y=146015
X7499 VSS: 2 VSS: 1520 1818 1261 118 2 MX2X1_HS $T=133860 146280 1 180 $X=129540 $Y=146015
X7502 VSS: 2 VSS: 1512 621 2 INVX2 $T=120980 154560 0 180 $X=119420 $Y=150115
X7507 VSS: 2 VSS: 1521 1520 1822 2 CLKAND2X2 $T=132020 154560 0 180 $X=129540 $Y=150115
X7513 VSS: 2 VSS: 1522 547 2 CLKINVX1_HS $T=116380 154560 0 0 $X=116200 $Y=154295
X7515 VSS: 2 VSS: 1523 621 1522 2 NOR2X2_HS $T=126040 154560 1 180 $X=122640 $Y=154295
X7518 VSS: 2 VSS: 1824 1521 2 BUFX16_HS $T=128340 154560 0 0 $X=128160 $Y=154295
X7520 VSS: 2 VSS: 1264 1221 1263 2 NOR2X1_HS $T=117760 162840 0 180 $X=115280 $Y=158395
X7523 VSS: 2 VSS: 1524 1527 1268 2 NAND2X1_HS $T=120520 162840 1 0 $X=120340 $Y=158395
X7526 VSS: 2 VSS: 1528 1525 addr_i[10] 2 NAND2X1 $T=128800 162840 0 180 $X=126780 $Y=158395
X7533 VSS: 2 VSS: 1527 770 2 INVX2 $T=120520 162840 0 0 $X=120340 $Y=162575
X7537 VSS: 2 VSS: 1832 1820 1575 2 NAND2X4_HS $T=136160 162840 1 180 $X=130920 $Y=162575
X7542 VSS: 2 VSS: 1529 1528 1530 2 NAND2X4_HS $T=129260 171120 0 180 $X=124020 $Y=166675
X7543 VSS: 2 VSS: 1833 1529 2 BUFX16_HS $T=129260 171120 1 0 $X=129080 $Y=166675
X7548 VSS: 2 VSS: 1532 1531 1266 976 68 2 AOI211X2_HS $T=118680 171120 0 0 $X=118500 $Y=170855
X7553 VSS: 2 VSS: 1531 1221 1228 1064 399 2 OAI22X1 $T=118680 179400 1 0 $X=118500 $Y=174955
X7558 VSS: 2 VSS: 1533 1532 2 CLKINVX1 $T=128340 179400 1 0 $X=128160 $Y=174955
X7564 VSS: 2 VSS: 1536 976 2 CLKINVX2_HS $T=119140 179400 1 180 $X=115280 $Y=179135
X7567 VSS: 2 VSS: 1535 addr_i[9] 2 INVX1 $T=120520 179400 0 0 $X=120340 $Y=179135
X7570 VSS: 2 VSS: 1537 410 addr_i[9] 2 NAND2X1 $T=126500 179400 1 180 $X=124480 $Y=179135
X7575 VSS: 2 VSS: 1538 70 559 1284 799 2 OAI22X2_HS $T=118680 187680 1 0 $X=118500 $Y=183235
X7579 VSS: 2 VSS: 1844 1845 2 BUFX16_HS $T=130640 187680 1 0 $X=130460 $Y=183235
X7586 VSS: 2 VSS: 1539 801 533 1285 1236 2 OAI22X1 $T=120980 187680 0 0 $X=120800 $Y=187415
X7590 VSS: 2 VSS: 1845 1537 1848 2 NAND2X4_HS $T=129720 187680 0 0 $X=129540 $Y=187415
X7592 VSS: 2 VSS: 1540 1274 1539 1538 2 NOR3X2_HS $T=124660 195960 0 180 $X=119880 $Y=191515
X7595 VSS: 2 VSS: 1853 1542 1541 2 NAND2X2_HS $T=129260 195960 1 0 $X=129080 $Y=191515
X7601 VSS: 2 VSS: 1543 71 802 73 1228 2 OAI22X1 $T=118220 195960 0 0 $X=118040 $Y=195695
X7605 VSS: 2 VSS: 1542 621 2 INVX2 $T=126960 195960 0 0 $X=126780 $Y=195695
X7610 VSS: 2 VSS: 1544 1221 72 801 399 2 OAI22X1 $T=121440 204240 1 0 $X=121260 $Y=199795
X7617 VSS: 2 VSS: 1545 1536 555 799 70 2 OAI22X1_HS $T=117300 204240 0 0 $X=117120 $Y=203975
X7618 VSS: 2 VSS: 1546 1543 1544 1545 2 NOR3X2_HS $T=125120 204240 1 180 $X=120340 $Y=203975
X7622 VSS: 2 VSS: 1859 576 1835 2 OR2X1 $T=131100 204240 0 0 $X=130920 $Y=203975
X7625 VSS: 2 VSS: 1549 1548 1278 1546 2 NAND3X2_HS $T=119600 212520 1 0 $X=119420 $Y=208075
X7628 VSS: 2 VSS: 1547 1549 2 BUFX4_HS $T=126960 212520 1 0 $X=126780 $Y=208075
X7634 VSS: 2 VSS: 1550 1536 555 801 71 2 OAI22X1_HS $T=116380 212520 0 0 $X=116200 $Y=212255
X7638 VSS: 2 VSS: 1865 addr_i[7] 2 INVX1 $T=130640 212520 0 0 $X=130460 $Y=212255
X7640 VSS: 2 VSS: 1551 1273 1550 1283 2 NOR3X2_HS $T=120060 220800 0 180 $X=115280 $Y=216355
X7641 VSS: 2 VSS: 1552 77 1281 1551 2 NAND3X2_HS $T=120060 220800 1 0 $X=119880 $Y=216355
X7643 VSS: 2 VSS: 1541 783 2 INVX4_HS $T=125120 220800 1 0 $X=124940 $Y=216355
X7645 VSS: 2 VSS: 1553 1868 2 BUFX16_HS $T=138920 220800 0 180 $X=128620 $Y=216355
X7651 VSS: 2 VSS: 1508 584 775 2 OR2X1_HS $T=125580 220800 0 0 $X=125400 $Y=220535
X7657 VSS: 2 VSS: 1555 786 2 BUFX2 $T=121900 229080 1 0 $X=121720 $Y=224635
X7660 VSS: 2 VSS: 1554 addr_i[8] 2 INVX1 $T=128800 229080 1 0 $X=128620 $Y=224635
X7668 VSS: 2 VSS: 1556 783 2 CLKBUFX2 $T=123280 229080 0 0 $X=123100 $Y=228815
X7672 VSS: 2 VSS: 1874 1555 775 2 OR2X1_HS $T=130640 229080 0 0 $X=130460 $Y=228815
X7675 VSS: 2 VSS: 1557 1558 1242 2 NOR2X1_HS $T=117760 237360 1 0 $X=117580 $Y=232915
X7679 VSS: 2 VSS: 1558 775 1556 2 NOR2X2_HS $T=128340 237360 0 180 $X=124940 $Y=232915
X7682 VSS: 2 VSS: 1879 1287 2 BUFX4_HS $T=131100 237360 1 0 $X=130920 $Y=232915
X7687 VSS: 2 VSS: 1560 813 1559 2 AND2X1_HS $T=122820 237360 1 180 $X=119880 $Y=237095
X7692 VSS: 2 VSS: 1559 1881 1287 118 2 MX2X1 $T=133400 237360 1 180 $X=129540 $Y=237095
X7694 VSS: 2 VSS: 1561 1560 2 BUFX8_HS $T=118680 245640 1 0 $X=118500 $Y=241195
X7697 VSS: 2 VSS: 1885 1884 2 BUFX16_HS $T=138920 245640 0 180 $X=128620 $Y=241195
X7702 VSS: 2 VSS: 1562 718 371 799 784 2 OAI22X1 $T=117760 245640 0 0 $X=117580 $Y=245375
X7710 VSS: 2 VSS: 1564 1562 1293 1563 2 NOR3X1_HS $T=126500 253920 1 0 $X=126320 $Y=249475
X7711 VSS: 2 VSS: 1888 1291 1565 1564 2 NAND3X1_HS $T=129260 253920 1 0 $X=129080 $Y=249475
X7716 VSS: 2 VSS: 1563 399 1566 1567 801 2 OAI22X1_HS $T=121900 253920 1 180 $X=118500 $Y=253655
X7719 VSS: 2 VSS: 1566 1023 2 CLKBUFX2_HS $T=127420 253920 0 0 $X=127240 $Y=253655
X7722 VSS: 2 VSS: 1567 330 2 CLKINVX2 $T=119140 262200 1 0 $X=118960 $Y=257755
X7726 VSS: 2 VSS: 1565 1568 1570 1569 1571 2 OAI211X1_HS $T=128800 262200 1 0 $X=128620 $Y=257755
X7731 VSS: 2 VSS: 1572 799 802 1295 718 2 OAI22X1 $T=117300 262200 0 0 $X=117120 $Y=261935
X7735 VSS: 2 VSS: 80 78 2 CLKINVX2 $T=132480 262200 1 180 $X=130920 $Y=261935
X7744 VSS: 2 VSS: 1573 393 1572 330 1294 2 AOI211X1_HS $T=117300 270480 0 0 $X=117120 $Y=270215
X7748 VSS: 2 VSS: 81 79 2 CLKINVX2_HS $T=126960 270480 0 0 $X=126780 $Y=270215
X7751 VSS: 2 VSS: 1530 415 864 2 NAND2X4_HS $T=116380 278760 1 0 $X=116200 $Y=274315
X7755 VSS: 2 VSS: 79 1574 2 INVX4_HS $T=129720 278760 0 180 $X=126320 $Y=274315
X7760 VSS: 2 VSS: 1575 415 433 2 NAND2X4_HS $T=115000 278760 0 0 $X=114820 $Y=278495
X7762 VSS: 2 VSS: 1548 82 1576 2 NAND2X2_HS $T=126960 278760 1 180 $X=123560 $Y=278495
X7766 VSS: 2 VSS: 1569 1574 2 INVX4_HS $T=130180 278760 0 0 $X=130000 $Y=278495
X7769 VSS: 2 VSS: 1577 1581 1580 2 NAND2X1 $T=119140 287040 0 180 $X=117120 $Y=282595
X7774 VSS: 2 VSS: 1576 1578 1577 1579 2 NAND3X2_HS $T=126040 287040 1 0 $X=125860 $Y=282595
X7781 VSS: 2 VSS: 1584 1308 2 CLKINVX1 $T=115460 287040 0 0 $X=115280 $Y=286775
X7786 VSS: 2 VSS: 1579 1583 1582 1574 2 NAND3X1_HS $T=126960 287040 0 0 $X=126780 $Y=286775
X7791 VSS: 2 VSS: 1580 1585 2 CLKINVX2 $T=124200 295320 0 180 $X=122640 $Y=290875
X7795 VSS: 2 VSS: 1582 1586 2 INVX2 $T=130640 295320 0 180 $X=129080 $Y=290875
X7801 VSS: 2 VSS: 1588 1584 1573 621 1589 2 OAI211X1_HS $T=118220 295320 0 0 $X=118040 $Y=295055
X7802 VSS: 2 VSS: 1590 1587 1588 118 2 MX2X1_HS $T=125580 295320 1 180 $X=121260 $Y=295055
X7809 VSS: 2 VSS: 1592 813 1590 2 AND2X1_HS $T=121440 303600 1 0 $X=121260 $Y=299155
X7812 VSS: 2 VSS: 1591 1583 1574 2 NAND2X2_HS $T=128800 303600 1 0 $X=128620 $Y=299155
X7819 VSS: 2 VSS: 1586 1581 2 INVX4_HS $T=120520 303600 0 0 $X=120340 $Y=303335
X7822 VSS: 2 VSS: 1914 1592 2 BUFX8_HS $T=127880 303600 0 0 $X=127700 $Y=303335
X7824 VSS: 2 VSS: 52 1594 2 INVX1_HS $T=118680 311880 0 180 $X=116660 $Y=307435
X7825 VSS: 2 VSS: 1593 1320 1319 1594 2 OAI21X2_HS $T=118680 311880 1 0 $X=118500 $Y=307435
X7828 VSS: 2 VSS: 1595 1593 2 CLKBUFX2 $T=125580 311880 1 0 $X=125400 $Y=307435
X7830 VSS: 2 VSS: 1574 1593 2 BUFX4_HS $T=128800 311880 1 0 $X=128620 $Y=307435
X7834 VSS: 2 VSS: 1594 1596 1321 1597 2 AOI21X2_HS $T=118220 311880 0 0 $X=118040 $Y=311615
X7839 VSS: 2 VSS: 1596 1600 1330 1601 2 OAI21X2_HS $T=116380 320160 1 0 $X=116200 $Y=315715
X7840 VSS: 2 VSS: 1597 1601 1602 2 NOR2X2_HS $T=124200 320160 0 180 $X=120800 $Y=315715
X7843 VSS: 2 VSS: 1603 1598 2 INVX1_HS $T=126960 320160 1 0 $X=126780 $Y=315715
X7844 VSS: 2 VSS: 1598 1325 1919 118 1599 2 AOI22X1_HS $T=132020 320160 0 180 $X=128620 $Y=315715
X7849 VSS: 2 VSS: 1327 1601 2 BUFX2 $T=120060 320160 1 180 $X=117580 $Y=319895
X7850 VSS: 2 VSS: 1601 385 1604 2 NOR2X2_HS $T=123280 320160 1 180 $X=119880 $Y=319895
X7854 VSS: 2 VSS: 1926 1605 2 BUFX16_HS $T=136620 320160 1 180 $X=126320 $Y=319895
X7856 VSS: 2 VSS: 1330 385 1604 2 NAND2X1_HS $T=115920 328440 1 0 $X=115740 $Y=323995
X7859 VSS: 2 VSS: 385 1606 2 BUFX8 $T=127880 328440 0 180 $X=122640 $Y=323995
X7860 VSS: 2 VSS: 1605 813 1603 2 AND2X1_HS $T=127880 328440 1 0 $X=127700 $Y=323995
X7861 VSS: 2 VSS: 1599 118 2 INVX2 $T=132020 328440 0 180 $X=130460 $Y=323995
X7866 VSS: 2 VSS: 1333 1602 2 CLKBUFX2 $T=120520 328440 1 180 $X=118040 $Y=328175
X7868 VSS: 2 VSS: 1602 384 1608 2 NOR2X2 $T=121440 328440 0 0 $X=121260 $Y=328175
X7871 VSS: 2 VSS: 1607 1595 2 CLKINVX2 $T=126500 328440 0 0 $X=126320 $Y=328175
X7875 VSS: 2 VSS: 1334 1600 2 CLKBUFX2 $T=118680 336720 0 180 $X=116200 $Y=332275
X7879 VSS: 2 VSS: 1589 82 1609 2 NAND2X2 $T=124200 336720 0 180 $X=121720 $Y=332275
X7882 VSS: 2 VSS: 1600 1608 384 2 NAND2X2_HS $T=132020 336720 0 180 $X=128620 $Y=332275
X7888 VSS: 2 VSS: 1609 1610 1611 2 XNOR2X1_HS $T=125120 336720 1 180 $X=120800 $Y=336455
X7889 VSS: 2 VSS: 1610 1613 1612 1607 2 OAI21X1 $T=127420 336720 1 180 $X=124940 $Y=336455
X7895 VSS: 2 VSS: 1612 1619 1618 1615 2 AOI21X1 $T=127420 345000 0 180 $X=124940 $Y=340555
X7903 VSS: 2 VSS: 1617 1347 1340 2 NOR2X2_HS $T=119600 345000 1 180 $X=116200 $Y=344735
X7906 VSS: 2 VSS: 1618 1621 2 INVX1 $T=122360 345000 0 0 $X=122180 $Y=344735
X7908 VSS: 2 VSS: 1613 1619 1620 2 NAND2X1 $T=127420 345000 0 0 $X=127240 $Y=344735
X7914 VSS: 2 VSS: 1581 1621 1619 2 NAND2X2 $T=122360 353280 1 0 $X=122180 $Y=348835
X7923 VSS: 2 VSS: 1621 1622 2 CLKBUFX2 $T=120980 353280 0 0 $X=120800 $Y=353015
X7925 VSS: 2 VSS: 1525 1623 2 BUFX8_HS $T=124200 353280 0 0 $X=124020 $Y=353015
X7928 VSS: 2 VSS: 118 1663 2 CLKBUFX4 $T=133860 353280 1 180 $X=130920 $Y=353015
X7929 VSS: 2 VSS: 1624 1363 2 BUFX4_HS $T=118220 361560 1 0 $X=118040 $Y=357115
X7932 VSS: 2 VSS: 1611 1626 1625 2 NAND2X1 $T=128340 361560 0 180 $X=126320 $Y=357115
X7938 VSS: 2 VSS: 410 1623 2 BUFX4_HS $T=126040 361560 1 180 $X=122180 $Y=361295
X7940 VSS: 2 VSS: 1619 1627 2 CLKINVX2 $T=131100 361560 1 180 $X=129540 $Y=361295
X7943 VSS: 2 VSS: 1630 415 427 addr_i[13] 2 OR3X1 $T=115460 369840 1 0 $X=115280 $Y=365395
X7946 VSS: 2 VSS: 1623 addr_i[12] 1630 2 NOR2X4 $T=126960 369840 0 180 $X=122640 $Y=365395
X7949 VSS: 2 VSS: 1835 1632 2 BUFX2 $T=131100 369840 1 0 $X=130920 $Y=365395
X7956 VSS: 2 VSS: 1631 1630 1633 2 NOR2X1 $T=117760 369840 0 0 $X=117580 $Y=369575
X7961 VSS: 2 VSS: 1632 1631 2 CLKINVX2 $T=126500 369840 0 0 $X=126320 $Y=369575
X7965 VSS: 2 VSS: 1634 r_en_i 1633 addr_i[13] 1635 2 NAND4X1 $T=117300 378120 1 0 $X=117120 $Y=373675
X7968 VSS: 2 VSS: 1633 addr_i[12] 2 INVX1 $T=125580 378120 0 180 $X=124020 $Y=373675
X7976 VSS: 2 VSS: 1638 1635 1639 2 NAND2X2_HS $T=120980 378120 0 0 $X=120800 $Y=377855
X7978 VSS: 2 VSS: 1637 1640 2 CLKBUFX8_HS $T=134780 378120 1 180 $X=125860 $Y=377855
X7980 VSS: 2 VSS: 1360 w_en_i r_en_i 2 NOR2X1 $T=116380 386400 1 0 $X=116200 $Y=381955
X7982 VSS: 2 VSS: 1635 427 1641 2 NOR2X1 $T=123740 386400 0 180 $X=121720 $Y=381955
X7985 VSS: 2 VSS: 1640 1360 1643 1632 2 OAI21X1_HS $T=128340 386400 1 0 $X=128160 $Y=381955
X7990 VSS: 2 VSS: 1361 1645 2 INVX1 $T=117300 386400 1 180 $X=115740 $Y=386135
X7995 VSS: 2 VSS: 1956 1644 1641 2 AND2X1 $T=129260 386400 0 0 $X=129080 $Y=386135
X8000 VSS: 2 VSS: 1647 1646 1641 2 AND2X1 $T=126960 394680 0 180 $X=124480 $Y=390235
X8009 VSS: 2 VSS: 1648 1650 2 BUFX2 $T=120520 394680 0 0 $X=120340 $Y=394415
X8013 VSS: 2 VSS: 1643 1649 97 2 NAND2X1_HS $T=128800 394680 0 0 $X=128620 $Y=394415
X8017 VSS: 2 VSS: 1652 1366 2 INVX2 $T=119140 402960 1 0 $X=118960 $Y=398515
X8019 VSS: 2 VSS: 1651 1650 2 CLKINVX2 $T=124200 402960 1 0 $X=124020 $Y=398515
X8022 VSS: 2 VSS: 1649 1651 1374 2 NAND2X1 $T=129720 402960 1 0 $X=129540 $Y=398515
X8028 VSS: 2 VSS: 1650 1653 1654 2 NOR2X1 $T=123280 402960 1 180 $X=121260 $Y=402695
X8034 VSS: 2 VSS: 1655 1652 1375 2 NOR2X2_HS $T=121900 411240 0 180 $X=118500 $Y=406795
X8036 VSS: 2 VSS: 1128 1656 2 BUFX2 $T=127880 411240 0 180 $X=125400 $Y=406795
X8037 VSS: 2 VSS: 1658 1657 2 INVX1 $T=129260 411240 0 180 $X=127700 $Y=406795
X8043 VSS: 2 VSS: 1375 1660 1659 2 NOR2X4_HS $T=115000 411240 0 0 $X=114820 $Y=410975
X8046 VSS: 2 VSS: 1654 1659 2 CLKBUFX2 $T=124660 411240 1 180 $X=122180 $Y=410975
X8050 VSS: 2 VSS: 1659 1133 1656 2 NAND2X4_HS $T=134780 411240 1 180 $X=129540 $Y=410975
X8051 VSS: 2 VSS: 1653 1369 1134 1379 2 NAND3X1 $T=115000 419520 1 0 $X=114820 $Y=415075
X8054 VSS: 2 VSS: 1660 1661 1662 2 NAND2X4_HS $T=125120 419520 0 180 $X=119880 $Y=415075
X8057 VSS: 2 VSS: 1661 1658 880 2 NOR2X2_HS $T=129720 419520 0 180 $X=126320 $Y=415075
X8063 VSS: 2 VSS: 1662 1134 2 INVX4_HS $T=118220 419520 0 0 $X=118040 $Y=419255
X8065 VSS: 2 VSS: 1665 1134 2 BUFX4_HS $T=123280 419520 0 0 $X=123100 $Y=419255
X8067 VSS: 2 VSS: 1666 880 2 CLKBUFX2 $T=128800 419520 0 0 $X=128620 $Y=419255
X8070 VSS: 2 VSS: 1667 1385 1384 2 NOR2X2_HS $T=119600 427800 0 180 $X=116200 $Y=423355
X8074 VSS: 2 VSS: 1669 1668 1667 2 NAND2X2_HS $T=124660 427800 1 0 $X=124480 $Y=423355
X8078 VSS: 2 VSS: 1966 1665 1968 2 NOR2X1 $T=131100 427800 1 0 $X=130920 $Y=423355
X8085 VSS: 2 VSS: 1668 1670 1138 691 2 OAI21X2_HS $T=122360 427800 0 0 $X=122180 $Y=427535
X8088 VSS: 2 VSS: 1388 691 694 2 NOR2X2_HS $T=118220 436080 0 180 $X=114820 $Y=431635
X8100 VSS: 2 VSS: 1671 1206 2 CLKBUFX2 $T=125580 436080 1 180 $X=123100 $Y=435815
X8117 VSS: 2 VSS: 1395 1677 1671 2 NAND2X2_HS $T=122360 452640 0 180 $X=118960 $Y=448195
X8127 VSS: 2 VSS: 1673 1676 1678 1983 1679 2 AOI22X2 $T=132020 452640 1 180 $X=127240 $Y=452375
X8128 VSS: 2 VSS: 1680 907 1675 2 NOR2X2_HS $T=115920 460920 1 0 $X=115740 $Y=456475
X8140 VSS: 2 VSS: 1401 1682 1985 2 AND2X2_HS $T=132480 460920 1 180 $X=129080 $Y=460655
X8145 VSS: 2 VSS: 1682 1989 1678 1983 1683 2 AOI22X1_HS $T=129720 469200 1 0 $X=129540 $Y=464755
X8151 VSS: 2 VSS: 1408 1687 1685 1688 1686 2 AOI22X2 $T=124660 469200 1 180 $X=119880 $Y=468935
X8157 VSS: 2 VSS: 1691 1690 2 BUFX8_HS $T=129720 477480 0 180 $X=124020 $Y=473035
X8169 VSS: 2 VSS: 1416 1691 1693 1694 1692 2 AOI22X1_HS $T=121440 485760 0 180 $X=118040 $Y=481315
X8179 VSS: 2 VSS: 1418 1687 1693 1694 1686 2 AOI22X1_HS $T=125580 485760 1 180 $X=122180 $Y=485495
X8192 VSS: 2 VSS: 1699 918 919 1697 1698 2 AOI22X2 $T=122360 494040 1 180 $X=117580 $Y=493775
X8200 VSS: 2 VSS: 1700 928 1698 1697 929 2 AOI22X2 $T=133400 502320 0 180 $X=128620 $Y=497875
X8212 VSS: 2 VSS: 1684 1705 1700 1704 1703 2 NAND4X2_HS $T=125580 510600 0 180 $X=119880 $Y=506155
X8222 VSS: 2 VSS: 1705 934 1702 1706 935 2 AOI22X2 $T=130180 510600 1 180 $X=125400 $Y=510335
X8228 VSS: 2 VSS: 1430 925 1702 1706 926 2 AOI22X2 $T=129720 518880 0 180 $X=124940 $Y=514435
X8235 VSS: 2 VSS: 1707 1708 1709 704 705 2 AOI22X1_HS $T=120980 518880 0 0 $X=120800 $Y=518615
X8240 VSS: 2 VSS: 1703 940 1709 1708 939 2 AOI22X2 $T=118680 527160 1 0 $X=118500 $Y=522715
X8255 VSS: 2 VSS: 1431 1712 1713 912 901 2 AOI22X1_HS $T=121440 535440 0 180 $X=118040 $Y=530995
X8259 VSS: 2 VSS: 2016 1710 1711 2 NAND2X4_HS $T=127880 535440 1 0 $X=127700 $Y=530995
X8264 VSS: 2 VSS: 1440 912 1714 1715 901 2 AOI22X2_HS $T=115460 535440 0 0 $X=115280 $Y=535175
X8268 VSS: 2 VSS: 1710 2019 1180 2 NOR2X4_HS $T=132020 535440 1 180 $X=126780 $Y=535175
X8273 VSS: 2 VSS: 1704 703 1712 1713 947 2 AOI22X2 $T=129720 543720 0 180 $X=124940 $Y=539275
X8280 VSS: 2 VSS: 1443 703 1715 1714 947 2 AOI22X2 $T=122360 543720 1 180 $X=117580 $Y=543455
X8287 VSS: 2 VSS: 1719 1425 1717 1718 1426 2 AOI22X2_HS $T=124200 552000 1 0 $X=124020 $Y=547555
X8304 VSS: 2 VSS: 1711 1725 1723 2 NOR2X4_HS $T=122360 560280 0 0 $X=122180 $Y=560015
X8308 VSS: 2 VSS: 1725 1456 1188 1727 1722 2 NAND4X2_HS $T=117300 568560 1 0 $X=117120 $Y=564115
X8323 VSS: 2 VSS: 962 1459 1719 1730 1191 2 NAND4X2_HS $T=117300 576840 1 0 $X=117120 $Y=572395
X8327 VSS: 2 VSS: 1727 1692 1728 1729 1691 2 AOI22X2_HS $T=131560 576840 0 180 $X=125860 $Y=572395
X8333 VSS: 2 VSS: 1724 1692 1731 1732 1691 2 AOI22X2_HS $T=122360 576840 1 180 $X=116660 $Y=576575
X8337 VSS: 2 VSS: 1730 1687 1729 1728 1686 2 AOI22X2_HS $T=125580 576840 0 0 $X=125400 $Y=576575
X8350 VSS: 2 VSS: 1469 1687 1732 1731 1686 2 AOI22X2_HS $T=118220 593400 1 0 $X=118040 $Y=588955
X8362 VSS: 2 VSS: 2038 1982 2035 2031 1676 2 AOI22X2_HS $T=136620 593400 1 180 $X=130920 $Y=593135
X8373 VSS: 2 VSS: 1471 1687 1733 1463 1686 2 AOI22X2_HS $T=118220 601680 0 0 $X=118040 $Y=601415
X8388 VSS: 2 VSS: 1737 1209 1701 1726 942 2 AOI22X1 $T=125580 609960 1 180 $X=122640 $Y=609695
X8393 VSS: 2 VSS: 1738 1736 1740 1739 1737 2 NAND4X1 $T=120980 618240 1 0 $X=120800 $Y=613795
X8420 VSS: 2 VSS: 1741 1982 2048 2045 1676 2 AOI22X2_HS $T=136620 626520 1 180 $X=130920 $Y=626255
X8433 VSS: 2 VSS: 1475 1742 1477 1741 2049 2 NAND4X4_HS $T=125120 634800 0 0 $X=124940 $Y=634535
X8439 VSS: 2 VSS: 970 1683 2048 2045 1989 2 AOI22X2 $T=135700 643080 0 180 $X=130920 $Y=638635
X8464 VSS: 2 VSS: 1487 486 190 2 NAND2X1_HS $T=144440 22080 1 180 $X=141960 $Y=21815
X8472 VSS: 2 VSS: 1743 635 2 INVX4 $T=143980 30360 1 0 $X=143800 $Y=25915
X8475 VSS: 2 VSS: 1486 493 275 2 NAND2X1 $T=135700 30360 0 0 $X=135520 $Y=30095
X8479 VSS: 2 VSS: 1744 635 2 INVX4 $T=144900 30360 1 180 $X=142420 $Y=30095
X8481 VSS: 2 VSS: 1745 1744 2057 2051 2 OAI21X2_HS $T=145820 30360 0 0 $X=145640 $Y=30095
X8485 VSS: 2 VSS: 1222 485 275 2 NAND2X1 $T=132940 38640 1 0 $X=132760 $Y=34195
X8490 VSS: 2 VSS: 1752 485 1745 2 NAND2X2 $T=149040 38640 0 180 $X=146560 $Y=34195
X8494 VSS: 2 VSS: 1746 485 1745 2 NOR2X4_HS $T=142140 38640 0 0 $X=141960 $Y=38375
X8500 VSS: 2 VSS: 1219 486 276 2 NAND2X2 $T=134320 46920 0 180 $X=131840 $Y=42475
X8504 VSS: 2 VSS: 1747 496 190 2 NAND2X1_HS $T=143060 46920 0 180 $X=140580 $Y=42475
X8508 VSS: 2 VSS: 485 2069 2 BUFX8_HS $T=151800 46920 0 180 $X=146100 $Y=42475
X8510 VSS: 2 VSS: 1750 493 271 2 NAND2X1 $T=135700 46920 1 180 $X=133680 $Y=46655
X8514 VSS: 2 VSS: 1749 1748 2 INVX1 $T=143520 46920 1 180 $X=141960 $Y=46655
X8515 VSS: 2 VSS: 1748 1746 2 CLKBUFX2 $T=145820 46920 1 180 $X=143340 $Y=46655
X8520 VSS: 2 VSS: 1751 1219 1750 1753 1747 2 NAND4X2_HS $T=132940 55200 1 0 $X=132760 $Y=50755
X8524 VSS: 2 VSS: 1755 1754 1749 2 NAND2X1 $T=143520 55200 0 180 $X=141500 $Y=50755
X8527 VSS: 2 VSS: 1754 1752 2 CLKBUFX2 $T=148120 55200 0 180 $X=145640 $Y=50755
X8529 VSS: 2 VSS: 1753 1494 275 2 NAND2X1 $T=132940 55200 0 0 $X=132760 $Y=54935
X8533 VSS: 2 VSS: 1757 1756 1493 2 OR2X1 $T=141220 55200 0 0 $X=141040 $Y=54935
X8535 VSS: 2 VSS: 493 2078 2 BUFX8 $T=150420 55200 1 180 $X=145180 $Y=54935
X8541 VSS: 2 VSS: 1760 1494 1758 2 NOR2X2_HS $T=132480 63480 1 0 $X=132300 $Y=59035
X8544 VSS: 2 VSS: 1761 1494 1758 2 NAND2X1_HS $T=137080 63480 1 0 $X=136900 $Y=59035
X8546 VSS: 2 VSS: 1759 1493 1756 2 NAND2X1 $T=141220 63480 1 0 $X=141040 $Y=59035
X8549 VSS: 2 VSS: 1762 1759 1757 2 NAND2X1 $T=145820 63480 1 0 $X=145640 $Y=59035
X8553 VSS: 2 VSS: 1764 1760 2 CLKBUFX2 $T=140760 63480 0 0 $X=140580 $Y=63215
X8555 VSS: 2 VSS: 1763 1764 2 CLKINVX1 $T=143520 63480 0 0 $X=143340 $Y=63215
X8557 VSS: 2 VSS: 1765 1761 1763 2 NAND2X1 $T=145360 63480 0 0 $X=145180 $Y=63215
X8564 VSS: 2 VSS: 1766 274 1767 2 NAND2X2 $T=138920 71760 1 0 $X=138740 $Y=67315
X8567 VSS: 2 VSS: 1768 1766 2 CLKBUFX2 $T=145820 71760 1 0 $X=145640 $Y=67315
X8572 VSS: 2 VSS: 1769 1766 1752 1746 2 OAI21X2_HS $T=149960 71760 1 180 $X=145180 $Y=71495
X8577 VSS: 2 VSS: 1498 1493 276 2 NAND2X1_HS $T=134780 80040 0 180 $X=132300 $Y=75595
X8579 VSS: 2 VSS: 1770 274 1767 2 NOR2X2_HS $T=138460 80040 1 0 $X=138280 $Y=75595
X8582 VSS: 2 VSS: 1771 1746 1770 2 NOR2X2 $T=146740 80040 0 180 $X=143800 $Y=75595
X8586 VSS: 2 VSS: 1773 1493 270 2 NAND2X1 $T=133860 80040 0 0 $X=133680 $Y=79775
X8589 VSS: 2 VSS: 1774 1770 2 BUFX2 $T=142140 80040 1 180 $X=139660 $Y=79775
X8591 VSS: 2 VSS: 1772 1746 1770 2 NOR2X2_HS $T=145820 80040 1 180 $X=142420 $Y=79775
X8593 VSS: 2 VSS: 2097 1771 2101 2 NAND2X4_HS $T=146740 80040 0 0 $X=146560 $Y=79775
X8599 VSS: 2 VSS: 1494 1775 2 CLKBUFX4 $T=140300 88320 0 180 $X=137360 $Y=83875
X8603 VSS: 2 VSS: 1777 1774 2 CLKINVX1 $T=144900 88320 0 180 $X=143340 $Y=83875
X8608 VSS: 2 VSS: 1779 1768 1777 2 NAND2X1 $T=143980 88320 1 180 $X=141960 $Y=88055
X8616 VSS: 2 VSS: 496 1780 2 BUFX8_HS $T=143520 96600 0 180 $X=137820 $Y=92155
X8622 VSS: 2 VSS: 1785 1784 1782 1783 2 OAI21X2_HS $T=142600 96600 1 180 $X=137820 $Y=96335
X8625 VSS: 2 VSS: 1782 1781 1786 1787 2 AOI21X2_HS $T=143980 96600 0 0 $X=143800 $Y=96335
X8631 VSS: 2 VSS: 1790 1755 1789 1785 2 OAI21X1_HS $T=137080 104880 1 0 $X=136900 $Y=100435
X8632 VSS: 2 VSS: 1789 1755 1785 2 NAND2X1_HS $T=142140 104880 0 180 $X=139660 $Y=100435
X8634 VSS: 2 VSS: 1784 1786 1788 2 NAND2X2 $T=148120 104880 0 180 $X=145640 $Y=100435
X8638 VSS: 2 VSS: 1793 1791 1790 2 NAND2X2_HS $T=141680 104880 1 180 $X=138280 $Y=104615
X8641 VSS: 2 VSS: 2119 1769 1772 1792 2 AOI21X2_HS $T=149040 104880 1 180 $X=144260 $Y=104615
X8645 VSS: 2 VSS: 1796 1508 1793 552 2 NAND3X1_HS $T=132020 113160 1 0 $X=131840 $Y=108715
X8649 VSS: 2 VSS: 1794 1509 2 CLKINVX1 $T=139840 113160 1 0 $X=139660 $Y=108715
X8650 VSS: 2 VSS: 1797 1795 1796 118 2 MX2X1_HS $T=145360 113160 0 180 $X=141040 $Y=108715
X8655 VSS: 2 VSS: 1798 1797 2 BUFX16_HS $T=148120 113160 1 180 $X=137820 $Y=112895
X8662 VSS: 2 VSS: 61 1253 2 CLKINVX1 $T=135240 121440 1 0 $X=135060 $Y=116995
X8666 VSS: 2 VSS: 1799 1255 1800 2 NAND2X2_HS $T=144440 121440 1 0 $X=144260 $Y=116995
X8669 VSS: 2 VSS: 1801 302 303 2 NOR2X4_HS $T=136620 121440 0 0 $X=136440 $Y=121175
X8676 VSS: 2 VSS: 206 1801 2 BUFX16_HS $T=133860 129720 1 0 $X=133680 $Y=125275
X8679 VSS: 2 VSS: 1800 1791 1803 2 NAND2X2_HS $T=148580 129720 0 180 $X=145180 $Y=125275
X8680 VSS: 2 VSS: 1808 1806 2 BUFX16_HS $T=141680 129720 1 180 $X=131380 $Y=129455
X8682 VSS: 2 VSS: 1805 1807 1804 2 NAND2X1_HS $T=143520 129720 0 0 $X=143340 $Y=129455
X8683 VSS: 2 VSS: 1803 1807 1805 1804 2 OAI21X1_HS $T=148580 129720 1 180 $X=145640 $Y=129455
X8688 VSS: 2 VSS: 1806 1810 1811 2 NAND2X2_HS $T=138920 138000 0 180 $X=135520 $Y=133555
X8692 VSS: 2 VSS: 1812 1519 1809 2 NAND2X2_HS $T=142140 138000 1 0 $X=141960 $Y=133555
X8697 VSS: 2 VSS: 1815 1813 1524 1017 2 NAND3X2_HS $T=133400 138000 0 0 $X=133220 $Y=137735
X8698 VSS: 2 VSS: 1811 118 1815 2 NAND2X2_HS $T=138000 138000 0 0 $X=137820 $Y=137735
X8700 VSS: 2 VSS: 1813 1791 1814 2 NAND2X4_HS $T=149960 138000 1 180 $X=144720 $Y=137735
X8709 VSS: 2 VSS: 1814 1816 1817 1819 2 OAI21X2_HS $T=145820 146280 1 0 $X=145640 $Y=141835
X8713 VSS: 2 VSS: 1817 1816 1819 2 NAND2X2_HS $T=143060 146280 1 180 $X=139660 $Y=146015
X8716 VSS: 2 VSS: 1804 2149 2148 1783 2 OAI21X2 $T=149500 146280 1 180 $X=145640 $Y=146015
X8723 VSS: 2 VSS: 1820 1525 addr_i[6] 2 NAND2X1 $T=138000 154560 1 0 $X=137820 $Y=150115
X8726 VSS: 2 VSS: 1809 1791 1821 2 NAND2X2_HS $T=147660 154560 0 180 $X=144260 $Y=150115
X8730 VSS: 2 VSS: 1821 1825 1827 1826 2 OAI21X1_HS $T=144440 154560 0 0 $X=144260 $Y=154295
X8736 VSS: 2 VSS: 1829 addr_i[10] 2 INVX1 $T=134320 162840 1 0 $X=134140 $Y=158395
X8739 VSS: 2 VSS: 178 1828 2 BUFX4_HS $T=141680 162840 0 180 $X=137820 $Y=158395
X8741 VSS: 2 VSS: 1827 1825 1826 2 NAND2X1_HS $T=147660 162840 0 180 $X=145180 $Y=158395
X8744 VSS: 2 VSS: 1826 1831 1830 1783 2 OAI21X2_HS $T=148120 162840 1 180 $X=143340 $Y=162575
X8748 VSS: 2 VSS: 2161 1832 2 BUFX16_HS $T=139380 171120 1 0 $X=139200 $Y=166675
X8750 VSS: 2 VSS: 1834 1829 1835 2 OR2X1 $T=135240 171120 0 0 $X=135060 $Y=170855
X8754 VSS: 2 VSS: 1792 2168 2167 2169 2 OAI21X2_HS $T=151340 171120 1 180 $X=146560 $Y=170855
X8759 VSS: 2 VSS: 1838 1533 1523 2 NOR2X2_HS $T=137080 179400 0 180 $X=133680 $Y=174955
X8762 VSS: 2 VSS: 1836 1837 2 BUFX8_HS $T=145360 179400 0 180 $X=139660 $Y=174955
X8766 VSS: 2 VSS: 1841 1535 1835 2 OR2X1 $T=131560 179400 0 0 $X=131380 $Y=179135
X8771 VSS: 2 VSS: 1837 1841 1842 2 NAND2X2_HS $T=142600 179400 0 0 $X=142420 $Y=179135
X8772 VSS: 2 VSS: 2174 1822 1840 2 AND2X1_HS $T=145820 179400 0 0 $X=145640 $Y=179135
X8778 VSS: 2 VSS: 1843 2174 2 BUFX16_HS $T=152260 187680 0 180 $X=141960 $Y=183235
X8781 VSS: 2 VSS: 1850 1849 2 CLKBUFX2_HS $T=136160 187680 0 0 $X=135980 $Y=187415
X8782 VSS: 2 VSS: 1847 1849 2 CLKBUFX2 $T=139380 187680 0 0 $X=139200 $Y=187415
X8785 VSS: 2 VSS: 1840 1846 1847 118 2 MX2X1_HS $T=148580 187680 1 180 $X=144260 $Y=187415
X8791 VSS: 2 VSS: 1849 1852 1540 1853 2 NAND3X2_HS $T=135240 195960 1 0 $X=135060 $Y=191515
X8793 VSS: 2 VSS: 1842 415 1850 2 NAND2X2_HS $T=143520 195960 1 0 $X=143340 $Y=191515
X8796 VSS: 2 VSS: 1848 415 464 2 NAND2X4_HS $T=137540 195960 1 180 $X=132300 $Y=195695
X8799 VSS: 2 VSS: 1854 1855 2 BUFX16_HS $T=150420 195960 1 180 $X=140120 $Y=195695
X8804 VSS: 2 VSS: 1857 addr_i[4] 415 1525 650 2 AOI22X2_HS $T=138920 204240 0 180 $X=133220 $Y=199795
X8808 VSS: 2 VSS: 1855 1857 2 CLKINVX2_HS $T=142140 204240 1 0 $X=141960 $Y=199795
X8812 VSS: 2 VSS: 1860 415 1547 2 NAND2X4_HS $T=135700 204240 0 0 $X=135520 $Y=203975
X8815 VSS: 2 VSS: 1858 1859 1860 2 NAND2X4_HS $T=143060 204240 0 0 $X=142880 $Y=203975
X8820 VSS: 2 VSS: 1862 addr_i[5] 415 1525 637 2 AOI22X2_HS $T=138460 212520 0 180 $X=132760 $Y=208075
X8822 VSS: 2 VSS: 1861 1862 2 INVX4_HS $T=140300 212520 1 0 $X=140120 $Y=208075
X8823 VSS: 2 VSS: 2188 1861 2 BUFX16_HS $T=143520 212520 1 0 $X=143340 $Y=208075
X8826 VSS: 2 VSS: 1866 1863 1549 118 2 MX2X1 $T=139840 212520 1 180 $X=135980 $Y=212255
X8829 VSS: 2 VSS: 1867 1864 1289 35 2 NAND3X2_HS $T=142600 212520 0 0 $X=142420 $Y=212255
X8835 VSS: 2 VSS: 1869 1870 2 BUFX16_HS $T=149040 220800 0 180 $X=138740 $Y=216355
X8836 VSS: 2 VSS: 1868 813 1866 2 AND2X1_HS $T=131560 220800 0 0 $X=131380 $Y=220535
X8839 VSS: 2 VSS: 1870 1871 1872 2 NAND2X4_HS $T=138460 220800 0 0 $X=138280 $Y=220535
X8841 VSS: 2 VSS: 2194 2182 2 CLKINVX1 $T=148580 220800 1 180 $X=147020 $Y=220535
X8846 VSS: 2 VSS: 1871 1554 1835 2 OR2X1 $T=132940 229080 1 0 $X=132760 $Y=224635
X8849 VSS: 2 VSS: 1872 415 1873 2 NAND2X4_HS $T=144440 229080 0 180 $X=139200 $Y=224635
X8853 VSS: 2 VSS: 1877 1779 1876 2 NAND2X2_HS $T=141220 229080 1 180 $X=137820 $Y=228815
X8854 VSS: 2 VSS: 1876 1851 1839 1875 2 OAI21X2_HS $T=145820 229080 1 180 $X=141040 $Y=228815
X8855 VSS: 2 VSS: 2201 2180 2194 1875 2 OAI21X2_HS $T=150420 229080 1 180 $X=145640 $Y=228815
X8860 VSS: 2 VSS: 1878 1779 1877 1876 2 OAI21X1_HS $T=136620 237360 1 0 $X=136440 $Y=232915
X8861 VSS: 2 VSS: 1880 1791 1878 2 NAND2X2_HS $T=142600 237360 0 180 $X=139200 $Y=232915
X8863 VSS: 2 VSS: 1875 1783 2 BUFX4_HS $T=143060 237360 1 0 $X=142880 $Y=232915
X8865 VSS: 2 VSS: 1884 1822 1882 2 AND2X1_HS $T=133400 237360 0 0 $X=133220 $Y=237095
X8868 VSS: 2 VSS: 1883 1557 1880 2 NAND2X2_HS $T=140760 237360 0 0 $X=140580 $Y=237095
X8875 VSS: 2 VSS: 1886 118 1883 2 NAND2X1_HS $T=141220 245640 1 0 $X=141040 $Y=241195
X8877 VSS: 2 VSS: 2211 2210 2207 118 2 MX2X1_HS $T=147200 245640 1 0 $X=147020 $Y=241195
X8879 VSS: 2 VSS: 1882 1887 1888 118 2 MX2X1 $T=132020 245640 0 0 $X=131840 $Y=245375
X8882 VSS: 2 VSS: 1890 1889 1886 2 NAND2X1_HS $T=141220 245640 0 0 $X=141040 $Y=245375
X8890 VSS: 2 VSS: 1873 1888 2 CLKBUFX2_HS $T=134780 253920 1 0 $X=134600 $Y=249475
X8894 VSS: 2 VSS: 1892 813 1890 2 CLKAND2X2 $T=141220 253920 1 0 $X=141040 $Y=249475
X8897 VSS: 2 VSS: 2015 1891 2 BUFX16_HS $T=144900 253920 1 0 $X=144720 $Y=249475
X8900 VSS: 2 VSS: 1893 1892 2 BUFX16_HS $T=147200 253920 1 180 $X=136900 $Y=253655
X8907 VSS: 2 VSS: 1571 1894 1569 2 NAND2X1 $T=134320 262200 0 180 $X=132300 $Y=257755
X8912 VSS: 2 VSS: 1568 95 93 2 OR2X1 $T=145360 262200 0 180 $X=142880 $Y=257755
X8916 VSS: 2 VSS: 1895 93 2 CLKINVX1 $T=141220 262200 1 180 $X=139660 $Y=261935
X8924 VSS: 2 VSS: 1894 94 95 2 AND2X1 $T=140760 270480 0 180 $X=138280 $Y=266035
X8928 VSS: 2 VSS: 2222 2224 82 2225 2 NAND3X2_HS $T=146740 270480 1 0 $X=146560 $Y=266035
X8930 VSS: 2 VSS: 78 94 1895 2 NAND2X1 $T=138000 270480 1 180 $X=135980 $Y=270215
X8935 VSS: 2 VSS: 2225 2226 2227 79 2228 2 OAI211X2_HS $T=146740 270480 0 0 $X=146560 $Y=270215
X8940 VSS: 2 VSS: 1852 1897 1899 1900 2 NAND3X4_HS $T=134320 278760 1 0 $X=134140 $Y=274315
X8943 VSS: 2 VSS: 1900 1898 1896 2 NAND2X2_HS $T=146740 278760 0 180 $X=143340 $Y=274315
X8946 VSS: 2 VSS: 1897 1901 1569 1902 2 NAND3X1_HS $T=137080 278760 0 0 $X=136900 $Y=278495
X8955 VSS: 2 VSS: 1905 82 2 CLKINVX2 $T=136620 287040 1 0 $X=136440 $Y=282595
X8959 VSS: 2 VSS: 1899 1904 1903 2 AND2X2_HS $T=141220 287040 1 0 $X=141040 $Y=282595
X8964 VSS: 2 VSS: 1903 1906 1905 2 NOR2X1_HS $T=136620 287040 0 0 $X=136440 $Y=286775
X8967 VSS: 2 VSS: 1898 1902 1907 2 NOR2X1_HS $T=144440 287040 0 0 $X=144260 $Y=286775
X8974 VSS: 2 VSS: 1906 1902 1901 2 NOR2X1_HS $T=135700 295320 1 0 $X=135520 $Y=290875
X8978 VSS: 2 VSS: 1904 1907 1902 1901 2 NAND3X1_HS $T=146740 295320 0 180 $X=143800 $Y=290875
X8981 VSS: 2 VSS: 1578 1591 1585 1586 2 NAND3X2_HS $T=137080 295320 1 180 $X=132300 $Y=295055
X8984 VSS: 2 VSS: 1910 1909 2 BUFX2_HS $T=144440 295320 1 180 $X=141500 $Y=295055
X8994 VSS: 2 VSS: 1583 1910 2 INVX2_HS $T=138460 303600 0 180 $X=135980 $Y=299155
X8997 VSS: 2 VSS: 1585 1911 2 CLKBUFX2 $T=143060 303600 0 180 $X=140580 $Y=299155
X9000 VSS: 2 VSS: 1909 2239 2241 2 NAND2X2_HS $T=150420 303600 0 180 $X=147020 $Y=299155
X9003 VSS: 2 VSS: 1908 1913 2 BUFX8_HS $T=137540 303600 0 0 $X=137360 $Y=303335
X9006 VSS: 2 VSS: 1901 1912 2 CLKINVX1 $T=146740 303600 1 180 $X=145180 $Y=303335
X9007 VSS: 2 VSS: 1911 2244 1912 2241 2 AOI21X2_HS $T=151340 303600 1 180 $X=146560 $Y=303335
X9013 VSS: 2 VSS: 1913 1916 1593 1915 2 AOI21X2_HS $T=139380 311880 0 180 $X=134600 $Y=307435
X9014 VSS: 2 VSS: 1783 1913 2 BUFX8_HS $T=139380 311880 1 0 $X=139200 $Y=307435
X9019 VSS: 2 VSS: 1915 1917 1909 2 NOR2X2_HS $T=136620 311880 0 0 $X=136440 $Y=311615
X9020 VSS: 2 VSS: 1916 1917 1918 1911 2 OAI21X2_HS $T=139840 311880 0 0 $X=139660 $Y=311615
X9027 VSS: 2 VSS: 1917 1922 1920 2 NAND2X2_HS $T=140760 320160 0 180 $X=137360 $Y=315715
X9028 VSS: 2 VSS: 1918 1923 1921 1922 2 AOI21X2_HS $T=145360 320160 0 180 $X=140580 $Y=315715
X9033 VSS: 2 VSS: 1922 1925 1924 2 NOR2X2_HS $T=144900 320160 1 180 $X=141500 $Y=319895
X9040 VSS: 2 VSS: 1927 82 1929 2 NAND2X4_HS $T=136160 328440 1 0 $X=135980 $Y=323995
X9043 VSS: 2 VSS: 1923 1925 1930 1928 2 OAI21X2_HS $T=143520 328440 1 0 $X=143340 $Y=323995
X9047 VSS: 2 VSS: 1933 1607 1932 1931 2 OAI21X1_HS $T=134780 328440 0 0 $X=134600 $Y=328175
X9048 VSS: 2 VSS: 1929 1933 1934 2 XNOR2X1_HS $T=137540 328440 0 0 $X=137360 $Y=328175
X9056 VSS: 2 VSS: 1932 1936 1935 1615 2 AOI21X1_HS $T=142140 336720 0 180 $X=139200 $Y=332275
X9062 VSS: 2 VSS: 1937 1938 1939 1607 2 OAI21X1_HS $T=134320 336720 0 0 $X=134140 $Y=336455
X9063 VSS: 2 VSS: 1614 1937 1940 2 XNOR2X1_HS $T=141220 336720 1 180 $X=136900 $Y=336455
X9066 VSS: 2 VSS: 1935 1921 2 CLKBUFX2 $T=145360 336720 0 0 $X=145180 $Y=336455
X9072 VSS: 2 VSS: 1939 1942 1941 1615 2 AOI21X1_HS $T=137540 345000 1 0 $X=137360 $Y=340555
X9075 VSS: 2 VSS: 1620 1910 2 INVX1_HS $T=132020 345000 0 0 $X=131840 $Y=344735
X9078 VSS: 2 VSS: 1938 1620 1942 2 NAND2X1_HS $T=136160 345000 0 0 $X=135980 $Y=344735
X9082 VSS: 2 VSS: 1936 1920 2 BUFX2 $T=141680 345000 0 0 $X=141500 $Y=344735
X9089 VSS: 2 VSS: 1931 1936 1620 2 NAND2X1 $T=136160 353280 0 180 $X=134140 $Y=348835
X9092 VSS: 2 VSS: 1921 1944 1943 1622 2 OAI21X2_HS $T=145360 353280 0 180 $X=140580 $Y=348835
X9097 VSS: 2 VSS: 1920 1944 1945 2 NOR2X2_HS $T=143520 353280 1 180 $X=140120 $Y=353015
X9105 VSS: 2 VSS: 1626 1943 2 CLKBUFX2 $T=135700 361560 0 180 $X=133220 $Y=357115
X9107 VSS: 2 VSS: 1625 1944 2 CLKINVX1 $T=140760 361560 0 180 $X=139200 $Y=357115
X9109 VSS: 2 VSS: 1943 448 1946 2 NAND2X2 $T=144900 361560 0 180 $X=142420 $Y=357115
X9111 VSS: 2 VSS: 1944 1947 1946 2 NOR2X4_HS $T=146740 361560 1 0 $X=146560 $Y=357115
X9114 VSS: 2 VSS: 1627 1945 2 BUFX2 $T=139380 361560 1 180 $X=136900 $Y=361295
X9117 VSS: 2 VSS: 1947 448 2 CLKBUFX2 $T=143980 361560 0 0 $X=143800 $Y=361295
X9124 VSS: 2 VSS: 1945 181 1948 2 NOR2X2_HS $T=138920 369840 1 0 $X=138740 $Y=365395
X9127 VSS: 2 VSS: 1949 1632 2 INVX4_HS $T=131560 369840 0 0 $X=131380 $Y=369575
X9130 VSS: 2 VSS: 1622 1948 181 2 NAND2X2_HS $T=142600 369840 1 180 $X=139200 $Y=369575
X9132 VSS: 2 VSS: 1948 2271 1950 2272 2 OAI21X2_HS $T=150880 369840 1 180 $X=146100 $Y=369575
X9138 VSS: 2 VSS: 1951 1646 1949 410 1644 2 AOI22X1 $T=134320 378120 1 0 $X=134140 $Y=373675
X9142 VSS: 2 VSS: 1950 2272 1952 2 NAND2X2_HS $T=148580 378120 0 180 $X=145180 $Y=373675
X9145 VSS: 2 VSS: 1953 1637 2 INVX1 $T=139840 378120 1 180 $X=138280 $Y=377855
X9149 VSS: 2 VSS: 1952 635 2 CLKINVX2 $T=144900 378120 0 0 $X=144720 $Y=377855
X9157 VSS: 2 VSS: 1954 1953 424 2 NOR2X1 $T=139840 386400 0 180 $X=137820 $Y=381955
X9160 VSS: 2 VSS: 2279 1638 2 INVX1 $T=148580 386400 0 180 $X=147020 $Y=381955
X9165 VSS: 2 VSS: 1957 631 cpu_halted_o 2 NOR2X1 $T=142140 386400 1 180 $X=140120 $Y=386135
X9168 VSS: 2 VSS: 1958 2279 424 2 NOR2X1 $T=148580 386400 1 180 $X=146560 $Y=386135
X9174 VSS: 2 VSS: 1644 8169 1954 90 2 DFFX1 $T=133860 394680 1 0 $X=133680 $Y=390235
X9177 VSS: 2 VSS: 1646 8170 1958 90 2 DFFX1 $T=143520 394680 1 0 $X=143340 $Y=390235
X9180 VSS: 2 VSS: 427 1959 1957 90 2 DFFX1 $T=134320 394680 0 0 $X=134140 $Y=394415
X9187 VSS: 2 VSS: 1960 1370 1371 90 2 DFFX1 $T=133860 402960 1 0 $X=133680 $Y=398515
X9190 VSS: 2 VSS: 89 1959 424 2 NOR2X1 $T=148580 402960 0 180 $X=146560 $Y=398515
X9191 VSS: 2 VSS: 1961 1374 424 2 NOR2X1 $T=131560 402960 0 0 $X=131380 $Y=402695
X9195 VSS: 2 VSS: cpu_halted_o 1960 2 BUFX2 $T=139840 402960 0 0 $X=139660 $Y=402695
X9198 VSS: 2 VSS: 2287 1962 2 INVX16_HS $T=153180 402960 1 180 $X=144720 $Y=402695
X9202 VSS: 2 VSS: 1657 1963 1956 2 NAND2X1 $T=133860 411240 0 180 $X=131840 $Y=406795
X9204 VSS: 2 VSS: 1963 8171 1961 90 2 DFFX1 $T=134780 411240 1 0 $X=134600 $Y=406795
X9206 VSS: 2 VSS: 1962 2291 2289 1655 2 NAND3X4_HS $T=151800 411240 0 180 $X=144720 $Y=406795
X9211 VSS: 2 VSS: 1964 1656 1133 2 NAND2X2_HS $T=141680 411240 0 0 $X=141500 $Y=410975
X9221 VSS: 2 VSS: 1965 1964 2 CLKINVX1_HS $T=143980 419520 1 0 $X=143800 $Y=415075
X9224 VSS: 2 VSS: 1663 1967 1966 2 NAND2X1 $T=134780 419520 1 180 $X=132760 $Y=419255
X9227 VSS: 2 VSS: 1967 1965 2 CLKBUFX2 $T=141220 419520 1 180 $X=138740 $Y=419255
X9230 VSS: 2 VSS: 2289 1666 1665 1965 2 AOI21X2_HS $T=146740 419520 0 0 $X=146560 $Y=419255
X9236 VSS: 2 VSS: 1138 1969 2 INVX8_HS $T=137080 427800 1 0 $X=136900 $Y=423355
X9239 VSS: 2 VSS: 1968 1666 2 CLKBUFX2 $T=133860 427800 1 180 $X=131380 $Y=427535
X9241 VSS: 2 VSS: 1970 1138 691 2 NOR2X4 $T=135700 427800 0 0 $X=135520 $Y=427535
X9243 VSS: 2 VSS: 691 1971 2 INVX8_HS $T=141680 427800 0 0 $X=141500 $Y=427535
X9249 VSS: 2 VSS: 1974 1973 1972 2 NAND2X4_HS $T=134780 436080 1 0 $X=134600 $Y=431635
X9256 VSS: 2 VSS: 1975 1974 2 INVX2_HS $T=138000 436080 0 0 $X=137820 $Y=435815
X9263 VSS: 2 VSS: 1973 1976 1206 2 NAND2X2 $T=136160 444360 0 180 $X=133680 $Y=439915
X9270 VSS: 2 VSS: 1675 1975 1979 1977 2 NAND3X2_HS $T=143980 444360 1 180 $X=139200 $Y=444095
X9277 VSS: 2 VSS: 1979 1676 1980 1981 1679 2 AOI22X2_HS $T=144440 452640 0 180 $X=138740 $Y=448195
X9281 VSS: 2 VSS: 1679 1982 2 BUFX8_HS $T=139380 452640 0 0 $X=139200 $Y=452375
X9290 VSS: 2 VSS: 1402 1677 1210 2 NAND2X1 $T=136160 460920 1 0 $X=135980 $Y=456475
X9294 VSS: 2 VSS: 2303 2307 1680 2 NAND2X1_HS $T=149500 460920 0 180 $X=147020 $Y=456475
X9299 VSS: 2 VSS: 1988 1984 1986 1987 2 NOR3X1 $T=145360 460920 0 0 $X=145180 $Y=460655
X9311 VSS: 2 VSS: 1992 1685 1991 1990 1980 2 AOI22X1 $T=141680 469200 1 180 $X=138740 $Y=468935
X9320 VSS: 2 VSS: 1993 1693 1991 1990 1678 2 AOI22X1 $T=141220 477480 1 0 $X=141040 $Y=473035
X9324 VSS: 2 VSS: 1987 1994 1992 1996 1995 2 NAND4X1 $T=136160 477480 0 0 $X=135980 $Y=477215
X9332 VSS: 2 VSS: 1994 913 1695 1716 1157 2 AOI22X1 $T=132940 485760 1 0 $X=132760 $Y=481315
X9340 VSS: 2 VSS: 2000 1999 2001 2002 2 NOR3X1 $T=136160 485760 0 0 $X=135980 $Y=485495
X9348 VSS: 2 VSS: 2002 1696 1993 2003 2004 2 NAND4X1 $T=132020 494040 1 0 $X=131840 $Y=489595
X9355 VSS: 2 VSS: 1995 1976 1701 1726 923 2 AOI22X1 $T=134780 494040 0 0 $X=134600 $Y=493775
X9360 VSS: 2 VSS: 941 7489 1914 2005 2 DFFX1_HS $T=146280 494040 0 0 $X=146100 $Y=493775
X9368 VSS: 2 VSS: 1706 7490 1893 2005 2 DFFX1_HS $T=141680 502320 1 0 $X=141500 $Y=497875
X9370 VSS: 2 VSS: 2004 1677 1701 1726 1702 2 AOI22X1 $T=132480 502320 0 0 $X=132300 $Y=502055
X9375 VSS: 2 VSS: 1176 7491 2015 2005 2 DFFX1_HS $T=147200 502320 0 0 $X=147020 $Y=502055
X9381 VSS: 2 VSS: 1997 916 2006 2007 1169 2 AOI22X1 $T=137540 510600 1 0 $X=137360 $Y=506155
X9388 VSS: 2 VSS: 2001 2009 2008 2010 2011 2 NAND4X1 $T=142600 510600 0 0 $X=142420 $Y=510335
X9396 VSS: 2 VSS: 1998 1688 2013 2012 1153 2 AOI22X1 $T=141680 518880 1 0 $X=141500 $Y=514435
X9402 VSS: 2 VSS: 2009 1694 2013 2012 1164 2 AOI22X1 $T=141220 518880 0 0 $X=141040 $Y=518615
X9408 VSS: 2 VSS: 2010 1709 2006 2007 1423 2 AOI22X1 $T=135240 527160 1 0 $X=135060 $Y=522715
X9413 VSS: 2 VSS: 1434 7492 1561 2014 2 DFFX1_HS $T=144900 527160 1 0 $X=144720 $Y=522715
X9414 VSS: 2 VSS: 1696 1713 1695 1716 1422 2 AOI22X1 $T=131560 527160 0 0 $X=131380 $Y=526895
X9420 VSS: 2 VSS: 1175 7493 2015 2014 2 DFFX1_HS $T=144900 527160 0 0 $X=144720 $Y=526895
X9426 VSS: 2 VSS: 1709 7494 1893 2017 2 DFFX1_HS $T=135700 535440 1 0 $X=135520 $Y=530995
X9428 VSS: 2 VSS: 942 7495 1914 2014 2 DFFX1_HS $T=146740 535440 1 0 $X=146560 $Y=530995
X9430 VSS: 2 VSS: 1437 7496 1561 2017 2 DFFX1_HS $T=133860 535440 0 0 $X=133680 $Y=535175
X9431 VSS: 2 VSS: 916 7497 2018 2017 2 DFFX1_HS $T=143060 535440 0 0 $X=142880 $Y=535175
X9438 VSS: 2 VSS: 945 7498 2015 2017 2 DFFX1_HS $T=135700 543720 1 0 $X=135520 $Y=539275
X9441 VSS: 2 VSS: 948 7499 1914 2017 2 DFFX1_HS $T=146280 543720 1 0 $X=146100 $Y=539275
X9444 VSS: 2 VSS: 2020 1437 2006 2007 1720 2 AOI22X1 $T=138920 543720 0 0 $X=138740 $Y=543455
X9455 VSS: 2 VSS: 2021 948 2006 2007 1183 2 AOI22X1 $T=143980 552000 1 0 $X=143800 $Y=547555
X9459 VSS: 2 VSS: 2022 945 2006 2007 1718 2 AOI22X1 $T=138460 552000 0 0 $X=138280 $Y=551735
X9465 VSS: 2 VSS: 1722 1166 1717 1718 1167 2 AOI22X2 $T=136620 560280 0 180 $X=131840 $Y=555835
X9470 VSS: 2 VSS: 913 7500 2018 2023 2 DFFX1_HS $T=145360 560280 1 0 $X=145180 $Y=555835
X9471 VSS: 2 VSS: 2025 2024 1701 1726 1175 2 AOI22X1 $T=137540 560280 1 180 $X=134600 $Y=560015
X9475 VSS: 2 VSS: 1713 7501 1893 2023 2 DFFX1_HS $T=145360 560280 0 0 $X=145180 $Y=560015
X9480 VSS: 2 VSS: 2026 2028 2029 2027 2025 2 NAND4X1 $T=134320 568560 1 0 $X=134140 $Y=564115
X9486 VSS: 2 VSS: 2028 1185 1695 1716 1457 2 AOI22X1 $T=132940 568560 0 0 $X=132760 $Y=568295
X9496 VSS: 2 VSS: 2030 2024 1210 2 NAND2X4 $T=136160 576840 1 0 $X=135980 $Y=572395
X9503 VSS: 2 VSS: 2029 1729 1991 1990 2031 2 AOI22X1 $T=139840 576840 0 0 $X=139660 $Y=576575
X9510 VSS: 2 VSS: 2019 2033 2034 2030 2032 2 NAND4X4_HS $T=134780 585120 1 0 $X=134600 $Y=580675
X9515 VSS: 2 VSS: 2034 1683 2035 2031 1989 2 AOI22X2_HS $T=138920 585120 1 180 $X=133220 $Y=584855
X9522 VSS: 2 VSS: 2036 1714 1695 1716 1465 2 AOI22X1 $T=134780 593400 1 0 $X=134600 $Y=588955
X9532 VSS: 2 VSS: 968 2040 2038 2037 2039 2 NAND4X4_HS $T=134780 601680 1 0 $X=134600 $Y=597235
X9536 VSS: 2 VSS: 1736 956 1695 1716 1204 2 AOI22X1 $T=135240 601680 0 0 $X=135060 $Y=601415
X9545 VSS: 2 VSS: 2041 1207 1701 1726 1434 2 AOI22X1 $T=141680 609960 0 180 $X=138740 $Y=605515
X9551 VSS: 2 VSS: 2042 2036 2043 2044 2041 2 NAND4X1 $T=139380 609960 0 0 $X=139200 $Y=609695
X9559 VSS: 2 VSS: 1740 1733 1991 1990 2045 2 AOI22X1 $T=139380 618240 1 0 $X=139200 $Y=613795
X9566 VSS: 2 VSS: 2043 1732 1991 1990 2046 2 AOI22X1 $T=139840 618240 0 0 $X=139660 $Y=617975
X9572 VSS: 2 VSS: 1480 1982 2047 2046 1676 2 AOI22X2_HS $T=137080 626520 0 180 $X=131380 $Y=622075
X9582 VSS: 2 VSS: 1484 1989 2046 2047 1683 2 AOI22X1 $T=134320 634800 0 180 $X=131380 $Y=630355
X9615 VSS: 2 VSS: rready_o 1951 1634 2 NAND2X2 $T=151800 22080 0 0 $X=151620 $Y=21815
X9619 VSS: 2 VSS: 2057 1743 2051 2 NAND2X2_HS $T=148120 30360 1 0 $X=147940 $Y=25915
X9622 VSS: 2 VSS: 2054 2052 2 CLKBUFX2 $T=153640 30360 1 0 $X=153460 $Y=25915
X9623 VSS: 2 VSS: 2056 2053 2 CLKBUFX2 $T=155940 30360 1 0 $X=155760 $Y=25915
X9626 VSS: 2 VSS: 2055 2056 2 CLKINVX1 $T=159620 30360 1 0 $X=159440 $Y=25915
X9628 VSS: 2 VSS: 2058 2054 2055 2 NAND2X1 $T=161460 30360 1 0 $X=161280 $Y=25915
X9631 VSS: 2 VSS: 2052 493 2059 2 NAND2X1 $T=152260 30360 0 0 $X=152080 $Y=30095
X9635 VSS: 2 VSS: 2061 635 2 INVX4 $T=157320 30360 0 0 $X=157140 $Y=30095
X9638 VSS: 2 VSS: 2051 2060 2 INVX2_HS $T=164220 30360 1 180 $X=161740 $Y=30095
X9640 VSS: 2 VSS: 2053 493 2059 2 NOR2X2_HS $T=152720 38640 1 0 $X=152540 $Y=34195
X9643 VSS: 2 VSS: 2063 2061 2062 2 NAND2X2 $T=158700 38640 1 0 $X=158520 $Y=34195
X9649 VSS: 2 VSS: 2066 2065 2052 2053 2 OAI21X2_HS $T=155020 38640 1 180 $X=150240 $Y=38375
X9651 VSS: 2 VSS: 2067 2064 2063 2062 2 OAI21X2_HS $T=163300 38640 1 180 $X=158520 $Y=38375
X9654 VSS: 2 VSS: 2065 486 2068 2 NAND2X2 $T=157780 46920 0 180 $X=155300 $Y=42475
X9657 VSS: 2 VSS: 2064 635 2 CLKINVX2 $T=163760 46920 0 180 $X=162200 $Y=42475
X9659 VSS: 2 VSS: 2070 496 2071 2 NOR2X4_HS $T=147660 46920 0 0 $X=147480 $Y=46655
X9661 VSS: 2 VSS: 2073 2053 2072 2 NOR2X2_HS $T=153640 46920 0 0 $X=153460 $Y=46655
X9664 VSS: 2 VSS: 2072 2068 486 2 NOR2X1_HS $T=161460 46920 1 180 $X=158980 $Y=46655
X9668 VSS: 2 VSS: 2074 496 2071 2 NAND2X1_HS $T=150420 55200 1 0 $X=150240 $Y=50755
X9670 VSS: 2 VSS: 2075 2072 2 BUFX2 $T=156400 55200 1 0 $X=156220 $Y=50755
X9673 VSS: 2 VSS: 2068 2356 635 2 XNOR2X1_HS $T=165600 55200 0 180 $X=161280 $Y=50755
X9676 VSS: 2 VSS: 2076 2074 2 CLKBUFX2 $T=151800 55200 0 0 $X=151620 $Y=54935
X9677 VSS: 2 VSS: 2079 2070 2 INVX4_HS $T=154100 55200 0 0 $X=153920 $Y=54935
X9679 VSS: 2 VSS: 2077 2079 2 CLKBUFX2 $T=157780 55200 0 0 $X=157600 $Y=54935
X9680 VSS: 2 VSS: 2080 2076 2077 2 NAND2X1 $T=160080 55200 0 0 $X=159900 $Y=54935
X9684 VSS: 2 VSS: 2081 2074 1761 1760 2 OAI21X1_HS $T=151800 63480 0 180 $X=148860 $Y=59035
X9687 VSS: 2 VSS: 2082 2074 2 INVX2_HS $T=153180 63480 1 0 $X=153000 $Y=59035
X9688 VSS: 2 VSS: 2083 2082 2079 2066 2 AOI21X2_HS $T=155480 63480 1 0 $X=155300 $Y=59035
X9691 VSS: 2 VSS: 1758 2358 635 2 XNOR2X1_HS $T=165600 63480 0 180 $X=161280 $Y=59035
X9692 VSS: 2 VSS: 2084 1760 2070 2 NOR2X1_HS $T=149040 63480 0 0 $X=148860 $Y=63215
X9695 VSS: 2 VSS: 2086 2066 2081 2084 2 AOI21X1_HS $T=155480 63480 1 180 $X=152540 $Y=63215
X9697 VSS: 2 VSS: 2087 2085 2 INVX2 $T=158700 63480 1 180 $X=157140 $Y=63215
X9698 VSS: 2 VSS: 2085 2066 2 BUFX2_HS $T=161460 63480 1 180 $X=158520 $Y=63215
X9703 VSS: 2 VSS: 2089 2084 2073 2 NAND2X1_HS $T=151340 71760 1 0 $X=151160 $Y=67315
X9705 VSS: 2 VSS: 2088 2079 2073 2 NAND2X2 $T=156400 71760 0 180 $X=153920 $Y=67315
X9708 VSS: 2 VSS: 2090 2075 2 CLKINVX1 $T=158700 71760 1 0 $X=158520 $Y=67315
X9711 VSS: 2 VSS: 1767 2361 635 2 XNOR2X1_HS $T=165600 71760 0 180 $X=161280 $Y=67315
X9714 VSS: 2 VSS: 2091 2073 2 CLKINVX1 $T=155480 71760 1 180 $X=153920 $Y=71495
X9716 VSS: 2 VSS: 2092 2065 2090 2 NAND2X1 $T=159160 71760 0 0 $X=158980 $Y=71495
X9718 VSS: 2 VSS: 2094 2097 2089 2 NOR2X2_HS $T=148580 80040 1 0 $X=148400 $Y=75595
X9719 VSS: 2 VSS: 2100 2098 2086 2089 2 OAI21X1_HS $T=151800 80040 1 0 $X=151620 $Y=75595
X9720 VSS: 2 VSS: 2096 2100 2094 1787 2 AOI21X2_HS $T=154560 80040 1 0 $X=154380 $Y=75595
X9721 VSS: 2 VSS: 2095 1783 2096 2099 2 OAI21X1_HS $T=159160 80040 1 0 $X=158980 $Y=75595
X9722 VSS: 2 VSS: 2093 2099 2096 1783 2 OAI21X1 $T=161920 80040 1 0 $X=161740 $Y=75595
X9725 VSS: 2 VSS: 1493 2102 2 CLKBUFX4 $T=156860 80040 1 180 $X=153920 $Y=79775
X9727 VSS: 2 VSS: 2099 2094 1788 2 NAND2X1_HS $T=160540 80040 0 0 $X=160360 $Y=79775
X9729 VSS: 2 VSS: 2108 2101 2 CLKINVX1 $T=149960 88320 0 180 $X=148400 $Y=83875
X9733 VSS: 2 VSS: 2106 2091 2087 2098 2 OAI21X1_HS $T=153180 88320 1 0 $X=153000 $Y=83875
X9734 VSS: 2 VSS: 2103 2106 2104 1787 2 AOI21X2_HS $T=155940 88320 1 0 $X=155760 $Y=83875
X9735 VSS: 2 VSS: 2107 2105 2103 1783 2 OAI21X2 $T=160540 88320 1 0 $X=160360 $Y=83875
X9737 VSS: 2 VSS: 1786 1774 2108 2 NOR2X2_HS $T=148120 88320 0 0 $X=147940 $Y=88055
X9740 VSS: 2 VSS: 2104 2091 2097 2 NOR2X2 $T=156400 88320 1 180 $X=153460 $Y=88055
X9742 VSS: 2 VSS: 2105 2104 1788 2 NAND2X1_HS $T=160080 88320 0 0 $X=159900 $Y=88055
X9744 VSS: 2 VSS: 1781 1774 1768 2111 2 OAI21X1_HS $T=150420 96600 0 180 $X=147480 $Y=92155
X9746 VSS: 2 VSS: 2110 2075 2097 2 NOR2X4 $T=156400 96600 0 180 $X=152080 $Y=92155
X9747 VSS: 2 VSS: 2109 2075 2065 2098 2 OAI21X2_HS $T=161000 96600 0 180 $X=156220 $Y=92155
X9748 VSS: 2 VSS: 2112 2109 2110 1787 2 AOI21X2_HS $T=161000 96600 1 0 $X=160820 $Y=92155
X9750 VSS: 2 VSS: 2115 2088 2097 2 NOR2X4_HS $T=154100 96600 1 180 $X=148860 $Y=96335
X9751 VSS: 2 VSS: 2116 2097 2 INVX2 $T=154100 96600 0 0 $X=153920 $Y=96335
X9753 VSS: 2 VSS: 2114 2110 1788 2 NAND2X2 $T=158240 96600 1 180 $X=155760 $Y=96335
X9755 VSS: 2 VSS: 2113 2114 2112 1783 2 OAI21X2_HS $T=158700 96600 0 0 $X=158520 $Y=96335
X9756 VSS: 2 VSS: 2379 2058 2113 2 NAND2X1_HS $T=163300 96600 0 0 $X=163120 $Y=96335
X9759 VSS: 2 VSS: 2118 2098 2 CLKINVX2 $T=155020 104880 0 180 $X=153460 $Y=100435
X9762 VSS: 2 VSS: 2117 2115 1788 2 NAND2X2_HS $T=159160 104880 1 0 $X=158980 $Y=100435
X9764 VSS: 2 VSS: 2098 2119 2 BUFX4_HS $T=149040 104880 0 0 $X=148860 $Y=104615
X9765 VSS: 2 VSS: 2120 2119 2 CLKBUFX2_HS $T=152720 104880 0 0 $X=152540 $Y=104615
X9766 VSS: 2 VSS: 2122 2088 2083 2120 2 OAI21X1_HS $T=155940 104880 0 0 $X=155760 $Y=104615
X9767 VSS: 2 VSS: 2123 2122 2115 2121 2 AOI21X2_HS $T=158700 104880 0 0 $X=158520 $Y=104615
X9773 VSS: 2 VSS: 2124 2117 2123 1908 2 OAI21X2_HS $T=162380 113160 0 180 $X=157600 $Y=108715
X9776 VSS: 2 VSS: 2111 1792 2 INVX1 $T=148580 113160 0 0 $X=148400 $Y=112895
X9779 VSS: 2 VSS: 2126 2116 1788 2 NAND2X2 $T=156400 113160 1 180 $X=153920 $Y=112895
X9785 VSS: 2 VSS: 2127 2118 2116 1787 2 AOI21X2_HS $T=153180 121440 1 0 $X=153000 $Y=116995
X9789 VSS: 2 VSS: 2390 118 1799 2 NAND2X2_HS $T=162840 121440 1 0 $X=162660 $Y=116995
X9791 VSS: 2 VSS: 2129 2126 2127 1908 2 OAI21X1_HS $T=152720 121440 0 0 $X=152540 $Y=121175
X9796 VSS: 2 VSS: 2387 2128 1802 1252 2 NAND3X2_HS $T=162380 121440 0 0 $X=162200 $Y=121175
X9799 VSS: 2 VSS: 2131 2092 2129 2 NAND2X1_HS $T=151340 129720 1 0 $X=151160 $Y=125275
X9800 VSS: 2 VSS: 2134 2092 2131 2129 2 OAI21X1_HS $T=156400 129720 0 180 $X=153460 $Y=125275
X9803 VSS: 2 VSS: 2128 1791 2130 2 NAND2X2_HS $T=159160 129720 1 0 $X=158980 $Y=125275
X9804 VSS: 2 VSS: 2130 2395 2132 2133 2 OAI21X1_HS $T=165140 129720 0 180 $X=162200 $Y=125275
X9807 VSS: 2 VSS: 2138 1014 2135 2 NAND2X1_HS $T=150880 129720 0 0 $X=150700 $Y=129455
X9808 VSS: 2 VSS: 2135 1791 2134 2 NAND2X1_HS $T=153180 129720 0 0 $X=153000 $Y=129455
X9811 VSS: 2 VSS: 2133 2136 2137 1783 2 OAI21X2_HS $T=162840 129720 1 180 $X=158060 $Y=129455
X9812 VSS: 2 VSS: 2132 2395 2133 2 NAND2X1_HS $T=165140 129720 1 180 $X=162660 $Y=129455
X9813 VSS: 2 VSS: 2139 2140 2 BUFX16_HS $T=158240 138000 0 180 $X=147940 $Y=133555
X9815 VSS: 2 VSS: 2137 2141 2 CLKINVX1 $T=159160 138000 1 0 $X=158980 $Y=133555
X9818 VSS: 2 VSS: 2140 2142 2138 118 2 MX2X1_HS $T=150420 138000 0 0 $X=150240 $Y=137735
X9820 VSS: 2 VSS: 2146 2144 2145 2 NOR2X2_HS $T=155020 138000 0 0 $X=154840 $Y=137735
X9823 VSS: 2 VSS: 2136 2143 2 CLKINVX1 $T=162380 138000 0 0 $X=162200 $Y=137735
X9827 VSS: 2 VSS: 1788 2146 2 CLKBUFX8_HS $T=160540 146280 0 180 $X=151620 $Y=141835
X9829 VSS: 2 VSS: 2143 2147 2 CLKBUFX2 $T=161460 146280 1 0 $X=161280 $Y=141835
X9831 VSS: 2 VSS: 1819 2144 2151 1908 2 OAI21X2_HS $T=154100 146280 1 180 $X=149320 $Y=146015
X9835 VSS: 2 VSS: 2152 2144 2 INVX2 $T=157320 146280 0 0 $X=157140 $Y=146015
X9837 VSS: 2 VSS: 2121 2150 2 CLKBUFX2 $T=159620 146280 0 0 $X=159440 $Y=146015
X9838 VSS: 2 VSS: 1787 2150 2 BUFX8_HS $T=161920 146280 0 0 $X=161740 $Y=146015
X9841 VSS: 2 VSS: 2151 2153 2 CLKBUFX2 $T=155480 154560 0 180 $X=153000 $Y=150115
X9844 VSS: 2 VSS: 2150 2145 2413 2411 2 OAI21X2_HS $T=162840 154560 1 0 $X=162660 $Y=150115
X9847 VSS: 2 VSS: 2149 2152 2154 2 NAND2X1_HS $T=152720 154560 1 180 $X=150240 $Y=154295
X9849 VSS: 2 VSS: 2148 2157 2155 2154 2 AOI21X2 $T=156860 154560 1 180 $X=153000 $Y=154295
X9852 VSS: 2 VSS: 2155 2153 2 INVX2_HS $T=158240 154560 0 0 $X=158060 $Y=154295
X9855 VSS: 2 VSS: 2153 2156 2414 2408 2 AOI21X2_HS $T=162840 154560 0 0 $X=162660 $Y=154295
X9859 VSS: 2 VSS: 1816 2158 2159 2 NAND2X1 $T=155940 162840 0 180 $X=153920 $Y=158395
X9862 VSS: 2 VSS: 2160 2158 2 INVX1 $T=162840 162840 0 180 $X=161280 $Y=158395
X9867 VSS: 2 VSS: 1831 2159 2152 2 NAND2X1 $T=155940 162840 1 180 $X=153920 $Y=162575
X9871 VSS: 2 VSS: 1830 2160 2159 2155 2 AOI21X2_HS $T=161000 162840 0 0 $X=160820 $Y=162575
X9874 VSS: 2 VSS: 2165 1834 2162 2 NAND2X4_HS $T=150880 171120 1 0 $X=150700 $Y=166675
X9877 VSS: 2 VSS: 2164 2163 2152 2 NAND2X1 $T=163300 171120 0 180 $X=161280 $Y=166675
X9881 VSS: 2 VSS: 2168 272 2067 2 NAND2X2_HS $T=160080 171120 1 180 $X=156680 $Y=170855
X9884 VSS: 2 VSS: 1839 2101 1792 1787 2 AOI21X1_HS $T=150420 179400 0 180 $X=147480 $Y=174955
X9888 VSS: 2 VSS: 2170 2168 2 BUFX2 $T=153640 179400 1 0 $X=153460 $Y=174955
X9892 VSS: 2 VSS: 2171 2067 272 2 NOR2X1_HS $T=159160 179400 1 0 $X=158980 $Y=174955
X9897 VSS: 2 VSS: 2172 2169 2 CLKINVX1 $T=153640 179400 0 0 $X=153460 $Y=179135
X9899 VSS: 2 VSS: 2101 2169 2171 2 NOR2X4_HS $T=156860 179400 0 0 $X=156680 $Y=179135
X9901 VSS: 2 VSS: 2173 2171 2 INVX1 $T=163760 179400 0 0 $X=163580 $Y=179135
X9904 VSS: 2 VSS: 2176 2167 2 CLKBUFX2 $T=155940 187680 0 180 $X=153460 $Y=183235
X9906 VSS: 2 VSS: 2169 284 2175 2 NOR2X4_HS $T=157780 187680 1 0 $X=157600 $Y=183235
X9911 VSS: 2 VSS: 2177 2176 2172 2 NAND2X1 $T=153640 187680 0 0 $X=153460 $Y=187415
X9913 VSS: 2 VSS: 2167 2175 284 2 NAND2X2 $T=161460 187680 1 180 $X=158980 $Y=187415
X9918 VSS: 2 VSS: 1851 2101 1788 2 NAND2X1 $T=149960 195960 1 0 $X=149780 $Y=191515
X9921 VSS: 2 VSS: 2179 2170 2173 2 NAND2X1 $T=155940 195960 0 180 $X=153920 $Y=191515
X9923 VSS: 2 VSS: 2178 2173 1788 2 NAND2X2_HS $T=157780 195960 1 0 $X=157600 $Y=191515
X9926 VSS: 2 VSS: 2180 1788 2 INVX1 $T=153640 195960 1 180 $X=152080 $Y=195695
X9929 VSS: 2 VSS: 2181 2170 2 CLKINVX2 $T=156400 195960 0 0 $X=156220 $Y=195695
X9934 VSS: 2 VSS: 2182 1787 2 CLKBUFX2 $T=150420 204240 0 180 $X=147940 $Y=199795
X9937 VSS: 2 VSS: 2183 2181 2173 1787 2 AOI21X2_HS $T=159620 204240 0 180 $X=154840 $Y=199795
X9944 VSS: 2 VSS: 2185 2177 2184 2 NAND2X1_HS $T=155020 204240 0 0 $X=154840 $Y=203975
X9945 VSS: 2 VSS: 2184 2178 2183 1908 2 OAI21X1_HS $T=160080 204240 1 180 $X=157140 $Y=203975
X9949 VSS: 2 VSS: 2187 2177 2185 2184 2 OAI21X1_HS $T=155480 212520 1 0 $X=155300 $Y=208075
X9950 VSS: 2 VSS: 1864 1791 2187 2 NAND2X2_HS $T=161460 212520 0 180 $X=158060 $Y=208075
X9953 VSS: 2 VSS: 2189 1865 1835 2 OR2X1 $T=149500 212520 0 0 $X=149320 $Y=212255
X9957 VSS: 2 VSS: 272 2016 2 BUFX4_HS $T=157780 212520 0 0 $X=157600 $Y=212255
X9961 VSS: 2 VSS: 2162 415 2190 2 NAND2X4_HS $T=150420 220800 1 0 $X=150240 $Y=216355
X9964 VSS: 2 VSS: 2191 118 1867 2 NAND2X2_HS $T=158240 220800 1 0 $X=158060 $Y=216355
X9971 VSS: 2 VSS: 2195 2192 2 CLKBUFX2 $T=155480 220800 0 0 $X=155300 $Y=220535
X9974 VSS: 2 VSS: 2450 2193 2 BUFX16_HS $T=160540 220800 0 0 $X=160360 $Y=220535
X9977 VSS: 2 VSS: 2196 415 1879 2 NAND2X4_HS $T=150880 229080 1 0 $X=150700 $Y=224635
X9980 VSS: 2 VSS: 2193 2198 2191 2 NAND2X2_HS $T=161920 229080 0 180 $X=158520 $Y=224635
X9983 VSS: 2 VSS: 2203 2179 2201 2 NAND2X2_HS $T=150880 229080 0 0 $X=150700 $Y=228815
X9986 VSS: 2 VSS: 2200 2199 1506 1874 2 NAND3X2_HS $T=155480 229080 0 0 $X=155300 $Y=228815
X9987 VSS: 2 VSS: 2199 1791 2202 2 NAND2X2_HS $T=160080 229080 0 0 $X=159900 $Y=228815
X9988 VSS: 2 VSS: 2202 2454 2455 2205 2 OAI21X1_HS $T=166060 229080 1 180 $X=163120 $Y=228815
X9990 VSS: 2 VSS: 2206 1791 2204 2 NAND2X1_HS $T=148120 237360 1 0 $X=147940 $Y=232915
X9992 VSS: 2 VSS: 2204 2179 2203 2201 2 OAI21X1_HS $T=150880 237360 1 0 $X=150700 $Y=232915
X9996 VSS: 2 VSS: 2205 2164 2166 1908 2 OAI21X2_HS $T=161460 237360 0 180 $X=156680 $Y=232915
X10000 VSS: 2 VSS: 2207 1225 2206 2 NAND2X1_HS $T=148120 237360 0 0 $X=147940 $Y=237095
X10004 VSS: 2 VSS: 2208 1908 2 BUFX4_HS $T=155480 237360 0 0 $X=155300 $Y=237095
X10009 VSS: 2 VSS: 2209 2186 2195 2208 2 OAI21X1_HS $T=159620 245640 0 180 $X=156680 $Y=241195
X10010 VSS: 2 VSS: 2212 2209 2197 2 NAND2X1_HS $T=159620 245640 1 0 $X=159440 $Y=241195
X10013 VSS: 2 VSS: 1891 813 2211 2 AND2X1_HS $T=151340 245640 1 180 $X=148400 $Y=245375
X10015 VSS: 2 VSS: 2214 2213 1791 2 NAND2X2_HS $T=158240 245640 1 180 $X=154840 $Y=245375
X10017 VSS: 2 VSS: 2213 2197 2212 2209 2 OAI21X1_HS $T=161460 245640 1 180 $X=158520 $Y=245375
X10021 VSS: 2 VSS: 2216 1030 2214 2 NAND2X2_HS $T=156400 253920 1 0 $X=156220 $Y=249475
X10024 VSS: 2 VSS: 2215 118 2 INVX2 $T=161920 253920 1 0 $X=161740 $Y=249475
X10026 VSS: 2 VSS: 2190 2219 2 CLKBUFX2_HS $T=149040 253920 0 0 $X=148860 $Y=253655
X10030 VSS: 2 VSS: 2220 813 2218 2 AND2X2_HS $T=158700 253920 1 180 $X=155300 $Y=253655
X10031 VSS: 2 VSS: 2218 2217 2216 118 2 MX2X1_HS $T=162840 253920 1 180 $X=158520 $Y=253655
X10034 VSS: 2 VSS: 2221 2219 2 CLKBUFX2_HS $T=149960 262200 1 0 $X=149780 $Y=257755
X10036 VSS: 2 VSS: 2018 2220 2 BUFX16_HS $T=155020 262200 1 0 $X=154840 $Y=257755
X10038 VSS: 2 VSS: 2219 606 2222 2 NAND2X2_HS $T=148120 262200 0 0 $X=147940 $Y=261935
X10041 VSS: 2 VSS: 1791 82 2 BUFX4 $T=159620 262200 1 180 $X=156680 $Y=261935
X10047 VSS: 2 VSS: 2223 94 82 95 2 OAI21X1_HS $T=157320 270480 1 0 $X=157140 $Y=266035
X10056 VSS: 2 VSS: 1896 1569 2 CLKINVX2 $T=151340 278760 0 180 $X=149780 $Y=274315
X10059 VSS: 2 VSS: 2228 2229 2 BUFX4_HS $T=154100 278760 1 0 $X=153920 $Y=274315
X10063 VSS: 2 VSS: 2224 2230 2231 2 NAND2X2_HS $T=152720 278760 1 180 $X=149320 $Y=278495
X10067 VSS: 2 VSS: 2230 2227 2 INVX2 $T=160080 278760 1 180 $X=158520 $Y=278495
X10072 VSS: 2 VSS: 2231 2226 2229 1569 2 OAI21X2_HS $T=154100 287040 0 180 $X=149320 $Y=282595
X10076 VSS: 2 VSS: 1902 2234 2233 2 NAND2X1 $T=164220 287040 0 180 $X=162200 $Y=282595
X10078 VSS: 2 VSS: 2226 2233 2236 2 NAND2X2 $T=153640 287040 1 180 $X=151160 $Y=286775
X10080 VSS: 2 VSS: 2237 2235 2 INVX1 $T=157320 287040 0 0 $X=157140 $Y=286775
X10084 VSS: 2 VSS: 2235 2234 2 CLKBUFX2 $T=164220 287040 1 180 $X=161740 $Y=286775
X10087 VSS: 2 VSS: 1907 2236 2 INVX1 $T=153180 295320 0 180 $X=151620 $Y=290875
X10090 VSS: 2 VSS: 2229 2237 2233 2238 2 AOI21X2_HS $T=157320 295320 1 0 $X=157140 $Y=290875
X10092 VSS: 2 VSS: 2236 2239 2 CLKBUFX2_HS $T=147660 295320 0 0 $X=147480 $Y=295055
X10096 VSS: 2 VSS: 93 2240 2 BUFX2 $T=158240 295320 1 180 $X=155760 $Y=295055
X10102 VSS: 2 VSS: 2239 2240 2242 2 NOR2X1_HS $T=158700 303600 0 180 $X=156220 $Y=299155
X10104 VSS: 2 VSS: 2232 2242 2 INVX1 $T=162380 303600 1 0 $X=162200 $Y=299155
X10108 VSS: 2 VSS: 2238 1912 2 BUFX2 $T=155480 303600 0 0 $X=155300 $Y=303335
X10109 VSS: 2 VSS: 1912 2243 2245 2242 2 OAI21X2_HS $T=162380 303600 1 180 $X=157600 $Y=303335
X10112 VSS: 2 VSS: 2247 1911 2 BUFX2 $T=150420 311880 0 180 $X=147940 $Y=307435
X10116 VSS: 2 VSS: 94 2243 2 BUFX2 $T=158700 311880 0 180 $X=156220 $Y=307435
X10119 VSS: 2 VSS: 2243 204 2246 2 NAND2X2_HS $T=163300 311880 0 180 $X=159900 $Y=307435
X10123 VSS: 2 VSS: 2248 1828 2 CLKBUFX2_HS $T=152260 311880 0 0 $X=152080 $Y=311615
X10128 VSS: 2 VSS: 1924 2248 2249 2 NOR2X2_HS $T=150880 320160 1 0 $X=150700 $Y=315715
X10131 VSS: 2 VSS: 1928 2248 2249 2 NAND2X2_HS $T=155480 320160 1 0 $X=155300 $Y=315715
X10134 VSS: 2 VSS: 2249 2498 635 2 XNOR2X1_HS $T=165600 320160 0 180 $X=161280 $Y=315715
X10137 VSS: 2 VSS: 2251 1924 2 BUFX2 $T=153640 320160 1 180 $X=151160 $Y=319895
X10141 VSS: 2 VSS: 2252 1925 2 CLKBUFX2 $T=159160 320160 1 180 $X=156680 $Y=319895
X10144 VSS: 2 VSS: 1925 2250 2499 2 NOR2X4_HS $T=161460 320160 0 0 $X=161280 $Y=319895
X10146 VSS: 2 VSS: 1934 1928 2253 2 NAND2X1 $T=151800 328440 0 180 $X=149780 $Y=323995
X10150 VSS: 2 VSS: 2254 2252 2 CLKINVX1 $T=156860 328440 1 0 $X=156680 $Y=323995
X10154 VSS: 2 VSS: 1930 2250 2499 2 NAND2X1_HS $T=163300 328440 1 0 $X=163120 $Y=323995
X10157 VSS: 2 VSS: 2253 2251 2 INVX1 $T=151800 328440 0 0 $X=151620 $Y=328175
X10160 VSS: 2 VSS: 1940 1930 2254 2 NAND2X1 $T=157780 328440 0 0 $X=157600 $Y=328175
X10163 VSS: 2 VSS: 2501 2016 964 2 XOR2X1_HS $T=163760 328440 0 0 $X=163580 $Y=328175
X10165 VSS: 2 VSS: 1615 2247 2 CLKINVX2 $T=148580 336720 1 0 $X=148400 $Y=332275
X10169 VSS: 2 VSS: 1608 2257 2255 2256 2 OAI21X2_HS $T=161000 336720 0 180 $X=156220 $Y=332275
X10174 VSS: 2 VSS: 2259 1935 2 INVX1 $T=150880 336720 0 0 $X=150700 $Y=336455
X10177 VSS: 2 VSS: 857 33 2258 2 NAND2X4_HS $T=161460 336720 1 180 $X=156220 $Y=336455
X10181 VSS: 2 VSS: 1941 2251 1928 2259 2 OAI21X1 $T=152720 345000 0 180 $X=150240 $Y=340555
X10184 VSS: 2 VSS: 2257 635 2 INVX4_HS $T=158240 345000 1 0 $X=158060 $Y=340555
X10187 VSS: 2 VSS: 2511 302 2 INVX8_HS $T=167900 345000 0 180 $X=162660 $Y=340555
X10189 VSS: 2 VSS: 1942 2260 2251 2 NOR2X1_HS $T=150880 345000 1 180 $X=148400 $Y=344735
X10193 VSS: 2 VSS: 2255 2261 2262 2 NAND2X2_HS $T=155940 345000 0 0 $X=155760 $Y=344735
X10198 VSS: 2 VSS: 2260 1936 2 INVX1 $T=149960 353280 1 0 $X=149780 $Y=348835
X10202 VSS: 2 VSS: 2261 635 2 INVX2 $T=157780 353280 0 180 $X=156220 $Y=348835
X10204 VSS: 2 VSS: 2349 639 2 CLKINVX8_HS $T=172960 353280 0 180 $X=161280 $Y=348835
X10209 VSS: 2 VSS: 2264 635 2263 2 NAND2X2_HS $T=157780 353280 0 0 $X=157600 $Y=353015
X10214 VSS: 2 VSS: 1946 635 2264 2263 2 OAI21X2_HS $T=156860 361560 1 0 $X=156680 $Y=357115
X10216 VSS: 2 VSS: 181 2265 2 BUFX8 $T=153180 361560 1 180 $X=147940 $Y=361295
X10221 VSS: 2 VSS: 2246 2266 2267 2 NAND2X2_HS $T=163300 361560 1 180 $X=159900 $Y=361295
X10225 VSS: 2 VSS: 2269 1106 2 CLKBUFX2 $T=149040 369840 1 0 $X=148860 $Y=365395
X10228 VSS: 2 VSS: 2268 635 2 INVX2 $T=157320 369840 0 180 $X=155760 $Y=365395
X10234 VSS: 2 VSS: 2270 2273 2 CLKINVX2_HS $T=156860 369840 0 0 $X=156680 $Y=369575
X10237 VSS: 2 VSS: 2272 480 639 2270 2269 2 OAI22X2_HS $T=152260 378120 1 0 $X=152080 $Y=373675
X10240 VSS: 2 VSS: 2266 2274 2520 2 NAND2X2_HS $T=163300 378120 1 0 $X=163120 $Y=373675
X10242 VSS: 2 VSS: 2271 635 2 CLKINVX2 $T=151800 378120 1 180 $X=150240 $Y=377855
X10245 VSS: 2 VSS: 2276 635 2 CLKINVX2 $T=157320 378120 1 180 $X=155760 $Y=377855
X10248 VSS: 2 VSS: 2277 639 2275 2 OR2X2 $T=160080 378120 0 0 $X=159900 $Y=377855
X10253 VSS: 2 VSS: 2274 2278 2276 2 NOR2X2_HS $T=158240 386400 0 180 $X=154840 $Y=381955
X10261 VSS: 2 VSS: 1645 2280 2281 1147 1381 2 OAI22X1 $T=160080 386400 1 180 $X=157140 $Y=386135
X10268 VSS: 2 VSS: 2275 262 2 INVX1 $T=162840 394680 0 180 $X=161280 $Y=390235
X10271 VSS: 2 VSS: 2282 896 1381 2 NAND2X4_HS $T=155480 394680 0 0 $X=155300 $Y=394415
X10275 VSS: 2 VSS: 480 2284 2 CLKINVX2 $T=154560 402960 0 180 $X=153000 $Y=398515
X10278 VSS: 2 VSS: 2284 2285 896 2283 2281 2 OAI22X1 $T=160080 402960 0 180 $X=157140 $Y=398515
X10283 VSS: 2 VSS: 2283 108 2286 2 NAND2X1 $T=160080 402960 1 180 $X=158060 $Y=402695
X10287 VSS: 2 VSS: 108 2527 2 BUFX2 $T=165600 402960 1 180 $X=163120 $Y=402695
X10288 VSS: 2 VSS: 2291 2290 2288 2 NAND2X2_HS $T=151800 411240 1 0 $X=151620 $Y=406795
X10292 VSS: 2 VSS: 1656 2292 2 CLKBUFX2_HS $T=164220 411240 0 180 $X=160820 $Y=406795
X10295 VSS: 2 VSS: 2295 1656 1133 2 OR2X1_HS $T=149960 411240 0 0 $X=149780 $Y=410975
X10296 VSS: 2 VSS: 2288 2295 2 INVX2_HS $T=152720 411240 0 0 $X=152540 $Y=410975
X10300 VSS: 2 VSS: 2292 2294 2293 1669 1390 2 OAI22X1_HS $T=164680 411240 1 180 $X=161280 $Y=410975
X10304 VSS: 2 VSS: 2285 1669 2 CLKBUFX2 $T=156860 419520 1 0 $X=156680 $Y=415075
X10307 VSS: 2 VSS: 107 2296 896 2 NAND2X2 $T=163300 419520 1 0 $X=163120 $Y=415075
X10311 VSS: 2 VSS: 2296 2285 2297 2 OR2X1 $T=159160 419520 0 0 $X=158980 $Y=419255
X10314 VSS: 2 VSS: 2290 1665 2 INVX2 $T=149960 427800 1 0 $X=149780 $Y=423355
X10318 VSS: 2 VSS: 2286 2298 1386 2 AND2X1 $T=157320 427800 1 0 $X=157140 $Y=423355
X10321 VSS: 2 VSS: 2297 2294 2 CLKBUFX2 $T=163760 427800 1 0 $X=163580 $Y=423355
X10323 VSS: 2 VSS: 2298 694 1970 2 NOR2X2_HS $T=154560 427800 1 180 $X=151160 $Y=427535
X10327 VSS: 2 VSS: 2294 1386 2298 2 NAND2X2_HS $T=160540 427800 0 0 $X=160360 $Y=427535
X10336 VSS: 2 VSS: 2300 2299 2 BUFX4_HS $T=160540 436080 1 180 $X=156680 $Y=435815
X10338 VSS: 2 VSS: 1977 2301 2 BUFX8_HS $T=156400 444360 0 180 $X=150700 $Y=439915
X10353 VSS: 2 VSS: 2304 1976 1210 2 NAND2X1 $T=148120 452640 0 0 $X=147940 $Y=452375
X10358 VSS: 2 VSS: 2302 2303 2 BUFX8_HS $T=158700 452640 0 0 $X=158520 $Y=452375
X10362 VSS: 2 VSS: 904 2304 2305 2300 2 NAND3X4_HS $T=164680 460920 0 180 $X=157600 $Y=456475
X10367 VSS: 2 VSS: 2305 2308 2309 2 AND2X1_HS $T=162380 460920 1 180 $X=159440 $Y=460655
X10373 VSS: 2 VSS: 2308 1989 1980 1981 1683 2 AOI22X1_HS $T=154560 469200 1 0 $X=154380 $Y=464755
X10379 VSS: 2 VSS: 2307 2310 1411 2 NOR2X2_HS $T=155480 469200 1 180 $X=152080 $Y=468935
X10388 VSS: 2 VSS: 2306 924 2312 2311 921 2 AOI22X1 $T=163760 477480 0 180 $X=160820 $Y=473035
X10392 VSS: 2 VSS: 2313 1706 2312 2311 1697 2 AOI22X1 $T=155480 477480 0 0 $X=155300 $Y=477215
X10396 VSS: 2 VSS: 1986 1998 2315 1997 2314 2 NAND4X1 $T=151340 485760 1 0 $X=151160 $Y=481315
X10403 VSS: 2 VSS: 2316 941 2312 2311 937 2 AOI22X1 $T=154560 485760 0 0 $X=154380 $Y=485495
X10408 VSS: 2 VSS: 2318 1435 2312 2311 1427 2 AOI22X1 $T=154100 494040 1 0 $X=153920 $Y=489595
X10414 VSS: 2 VSS: 2566 1176 2312 2311 922 2 AOI22X1 $T=163760 494040 0 0 $X=163580 $Y=493775
X10416 VSS: 2 VSS: 924 7502 2018 2005 2 DFFX1_HS $T=152720 502320 1 0 $X=152540 $Y=497875
X10419 VSS: 2 VSS: 1697 7503 1893 2321 2 DFFX1_HS $T=160080 502320 0 0 $X=159900 $Y=502055
X10421 VSS: 2 VSS: 1435 7504 1561 2005 2 DFFX1_HS $T=149500 510600 1 0 $X=149320 $Y=506155
X10423 VSS: 2 VSS: 921 7505 2018 2321 2 DFFX1_HS $T=159620 510600 1 0 $X=159440 $Y=506155
X10425 VSS: 2 VSS: 1427 7506 1561 2321 2 DFFX1_HS $T=149500 510600 0 0 $X=149320 $Y=510335
X10426 VSS: 2 VSS: 937 7507 1914 2321 2 DFFX1_HS $T=158700 510600 0 0 $X=158520 $Y=510335
X10430 VSS: 2 VSS: 1708 7508 1893 2322 2 DFFX1_HS $T=157320 518880 1 0 $X=157140 $Y=514435
X10434 VSS: 2 VSS: 922 7509 2015 2321 2 DFFX1_HS $T=154100 518880 0 0 $X=153920 $Y=518615
X10436 VSS: 2 VSS: 1702 7510 1893 2014 2 DFFX1_HS $T=154100 527160 1 0 $X=153920 $Y=522715
X10438 VSS: 2 VSS: 923 7511 2018 2014 2 DFFX1_HS $T=163760 527160 1 0 $X=163580 $Y=522715
X10441 VSS: 2 VSS: 1694 7512 1893 2323 2 DFFX1_HS $T=156860 527160 0 0 $X=156680 $Y=526895
X10444 VSS: 2 VSS: 1688 7513 2018 2323 2 DFFX1_HS $T=157320 535440 1 0 $X=157140 $Y=530995
X10446 VSS: 2 VSS: 1164 7514 1893 2324 2 DFFX1_HS $T=152720 535440 0 0 $X=152540 $Y=535175
X10448 VSS: 2 VSS: 1153 7515 2018 2324 2 DFFX1_HS $T=162380 535440 0 0 $X=162200 $Y=535175
X10450 VSS: 2 VSS: 1169 7516 2018 2325 2 DFFX1_HS $T=157320 543720 1 0 $X=157140 $Y=539275
X10453 VSS: 2 VSS: 1183 7517 1914 2325 2 DFFX1_HS $T=153640 543720 0 0 $X=153460 $Y=543455
X10458 VSS: 2 VSS: 1720 7518 1561 2325 2 DFFX1_HS $T=156400 552000 1 0 $X=156220 $Y=547555
X10462 VSS: 2 VSS: 1718 7519 2015 2325 2 DFFX1_HS $T=154560 552000 0 0 $X=154380 $Y=551735
X10465 VSS: 2 VSS: 1714 7520 1561 2023 2 DFFX1_HS $T=156400 560280 1 0 $X=156220 $Y=555835
X10468 VSS: 2 VSS: 1185 7521 2015 2023 2 DFFX1_HS $T=157320 560280 0 0 $X=157140 $Y=560015
X10470 VSS: 2 VSS: 2326 2328 2327 2026 2 NOR3X1 $T=151800 568560 1 0 $X=151620 $Y=564115
X10473 VSS: 2 VSS: 956 7522 1914 2023 2 DFFX1_HS $T=161460 568560 1 0 $X=161280 $Y=564115
X10476 VSS: 2 VSS: 2327 2330 2329 2022 2331 2 NAND4X1 $T=155020 568560 0 0 $X=154840 $Y=568295
X10481 VSS: 2 VSS: 2330 1728 2013 2012 1190 2 AOI22X1 $T=149040 576840 1 0 $X=148860 $Y=572395
X10485 VSS: 2 VSS: 1728 7523 2015 2323 2 DFFX1_HS $T=158240 576840 1 0 $X=158060 $Y=572395
X10488 VSS: 2 VSS: 1190 7524 2015 2324 2 DFFX1_HS $T=151340 576840 0 0 $X=151160 $Y=576575
X10497 VSS: 2 VSS: 1194 7525 1914 2324 2 DFFX1_HS $T=153180 585120 0 0 $X=153000 $Y=584855
X10500 VSS: 2 VSS: 2037 2024 1206 2 NAND2X1_HS $T=151340 593400 0 180 $X=148860 $Y=588955
X10504 VSS: 2 VSS: 1463 7526 1914 2323 2 DFFX1_HS $T=159160 593400 1 0 $X=158980 $Y=588955
X10508 VSS: 2 VSS: 2332 1463 2013 2012 1194 2 AOI22X1 $T=156860 593400 0 0 $X=156680 $Y=593135
X10519 VSS: 2 VSS: 2333 1731 2013 2012 1186 2 AOI22X1 $T=155480 601680 0 0 $X=155300 $Y=601415
X10524 VSS: 2 VSS: 2335 2334 2336 2042 2 NOR3X1 $T=153640 609960 1 0 $X=153460 $Y=605515
X10530 VSS: 2 VSS: 2339 2332 2337 2021 2338 2 NAND4X1 $T=153640 609960 0 0 $X=153460 $Y=609695
X10537 VSS: 2 VSS: 2336 2333 2341 2020 2340 2 NAND4X1 $T=155480 618240 1 0 $X=155300 $Y=613795
X10542 VSS: 2 VSS: 1186 7527 1561 2324 2 DFFX1_HS $T=152260 618240 0 0 $X=152080 $Y=617975
X10554 VSS: 2 VSS: 1479 2599 2 CLKBUFX2_HS $T=166520 626520 1 180 $X=163120 $Y=626255
X10561 VSS: 2 VSS: 2599 2544 2598 2597 2600 2 AOI22X2_HS $T=168820 634800 0 180 $X=163120 $Y=630355
X10564 VSS: 2 VSS: 2049 2342 2 BUFX4_HS $T=153640 634800 1 180 $X=149780 $Y=634535
X10593 VSS: 2 VSS: 2343 2344 2 CLKBUFX4 $T=176180 22080 1 0 $X=176000 $Y=17635
X10602 VSS: 2 VSS: 2344 addr_i[4] 2345 addr_i[2] addr_i[3] 2 NOR4X1 $T=179400 22080 1 180 $X=176460 $Y=21815
X10622 VSS: 2 VSS: 2062 2350 2 INVX2_HS $T=166520 38640 0 180 $X=164040 $Y=34195
X10624 VSS: 2 VSS: 2350 2349 1624 2348 964 2 AOI22X2_HS $T=173880 38640 0 180 $X=168180 $Y=34195
X10628 VSS: 2 VSS: 2060 2349 1624 2348 2612 2 AOI22X2_HS $T=177100 38640 1 0 $X=176920 $Y=34195
X10641 VSS: 2 VSS: 2353 635 2351 2 NAND2X2_HS $T=166980 46920 1 0 $X=166800 $Y=42475
X10644 VSS: 2 VSS: 2059 2352 635 2 XNOR2X1_HS $T=176640 46920 0 180 $X=172320 $Y=42475
X10653 VSS: 2 VSS: 2071 635 2353 2351 2 OAI21X2_HS $T=166520 46920 0 0 $X=166340 $Y=46655
X10656 VSS: 2 VSS: 2351 2349 1624 2348 2354 2 AOI22X2_HS $T=176640 46920 0 0 $X=176460 $Y=46655
X10661 VSS: 2 VSS: 486 2355 2 BUFX8 $T=171580 55200 0 180 $X=166340 $Y=50755
X10665 VSS: 2 VSS: 2352 2349 1624 2348 2618 2 AOI22X2_HS $T=177560 55200 1 0 $X=177380 $Y=50755
X10681 VSS: 2 VSS: 2358 2348 1624 2349 2357 2 AOI22X2_HS $T=168820 63480 1 0 $X=168640 $Y=59035
X10684 VSS: 2 VSS: 2356 2348 1624 2349 2620 2 AOI22X2_HS $T=178940 63480 1 0 $X=178760 $Y=59035
X10696 VSS: 2 VSS: 1756 2359 635 2 CLKXOR2X1 $T=168820 71760 0 180 $X=165420 $Y=67315
X10697 VSS: 2 VSS: 2361 2348 1624 2349 1145 2 AOI22X2_HS $T=168820 71760 1 0 $X=168640 $Y=67315
X10699 VSS: 2 VSS: 2359 2360 2 INVX1 $T=176180 71760 0 180 $X=174620 $Y=67315
X10702 VSS: 2 VSS: 2360 2624 2349 1624 2348 2 AOI22X1 $T=180320 71760 1 0 $X=180140 $Y=67315
X10709 VSS: 2 VSS: 2363 2362 2 INVX2_HS $T=175720 71760 0 0 $X=175540 $Y=71495
X10711 VSS: 2 VSS: 2362 2348 1624 2349 2604 2 AOI22X2_HS $T=179860 71760 0 0 $X=179680 $Y=71495
X10715 VSS: 2 VSS: 2368 1762 2095 2 NAND2X1_HS $T=164220 80040 1 0 $X=164040 $Y=75595
X10716 VSS: 2 VSS: 2364 1762 2368 2093 2 OAI21X1_HS $T=166520 80040 1 0 $X=166340 $Y=75595
X10717 VSS: 2 VSS: 2365 1791 2364 2 NAND2X2_HS $T=169280 80040 1 0 $X=169100 $Y=75595
X10718 VSS: 2 VSS: 2366 1233 2365 2 NAND2X2_HS $T=172500 80040 1 0 $X=172320 $Y=75595
X10719 VSS: 2 VSS: 2369 118 2366 2 NAND2X2_HS $T=175720 80040 1 0 $X=175540 $Y=75595
X10720 VSS: 2 VSS: 2626 2367 2 BUFX16_HS $T=178940 80040 1 0 $X=178760 $Y=75595
X10728 VSS: 2 VSS: 2367 2628 2369 2 NAND2X2_HS $T=182620 80040 1 180 $X=179220 $Y=79775
X10732 VSS: 2 VSS: 2372 2080 2107 2 NAND2X1_HS $T=164220 88320 1 0 $X=164040 $Y=83875
X10733 VSS: 2 VSS: 2370 2080 2372 2107 2 OAI21X1_HS $T=166520 88320 1 0 $X=166340 $Y=83875
X10734 VSS: 2 VSS: 2375 1791 2370 2 NAND2X2_HS $T=169280 88320 1 0 $X=169100 $Y=83875
X10735 VSS: 2 VSS: 2374 635 2 CLKINVX2 $T=172500 88320 1 0 $X=172320 $Y=83875
X10736 VSS: 2 VSS: 2373 2374 2371 2363 2 OAI21X2_HS $T=173880 88320 1 0 $X=173700 $Y=83875
X10737 VSS: 2 VSS: 2371 2630 2363 2 NAND2X2 $T=180780 88320 0 180 $X=178300 $Y=83875
X10743 VSS: 2 VSS: 2377 1500 2375 2 NAND2X2_HS $T=167900 88320 0 0 $X=167720 $Y=88055
X10745 VSS: 2 VSS: 2376 118 2377 2 NAND2X2_HS $T=175260 88320 1 180 $X=171860 $Y=88055
X10749 VSS: 2 VSS: 2635 2633 2376 2 NAND2X2_HS $T=181700 88320 1 180 $X=178300 $Y=88055
X10757 VSS: 2 VSS: 2636 2635 2 BUFX16_HS $T=185380 96600 0 180 $X=175080 $Y=92155
X10762 VSS: 2 VSS: 2380 2058 2379 2113 2 OAI21X1_HS $T=165600 96600 0 0 $X=165420 $Y=96335
X10763 VSS: 2 VSS: 2378 1791 2380 2 NAND2X2_HS $T=171580 96600 1 180 $X=168180 $Y=96335
X10764 VSS: 2 VSS: 2381 2378 1794 739 2 NAND3X2_HS $T=171580 96600 0 0 $X=171400 $Y=96335
X10765 VSS: 2 VSS: 2382 118 2381 2 NAND2X2_HS $T=176180 96600 0 0 $X=176000 $Y=96335
X10767 VSS: 2 VSS: 2639 2641 2382 2 NAND2X2_HS $T=183540 96600 1 180 $X=180140 $Y=96335
X10776 VSS: 2 VSS: 2643 2639 2 BUFX16_HS $T=186760 104880 0 180 $X=176460 $Y=100435
X10781 VSS: 2 VSS: 2385 1765 2384 2124 2 OAI21X1_HS $T=167900 104880 0 0 $X=167720 $Y=104615
X10782 VSS: 2 VSS: 2383 1791 2385 2 NAND2X2_HS $T=170660 104880 0 0 $X=170480 $Y=104615
X10786 VSS: 2 VSS: 2644 2383 1247 527 2 NAND3X2_HS $T=179860 104880 0 0 $X=179680 $Y=104615
X10792 VSS: 2 VSS: 2384 1765 2124 2 NAND2X1_HS $T=172500 113160 0 180 $X=170020 $Y=108715
X10799 VSS: 2 VSS: 2125 2386 2 BUFX16_HS $T=174800 113160 1 180 $X=164500 $Y=112895
X10802 VSS: 2 VSS: 2648 2649 2 BUFX16_HS $T=189060 113160 1 180 $X=178760 $Y=112895
X10807 VSS: 2 VSS: 2388 118 2387 2 NAND2X2_HS $T=167900 121440 1 0 $X=167720 $Y=116995
X10809 VSS: 2 VSS: 2386 2389 2388 2 NAND2X2_HS $T=176180 121440 0 180 $X=172780 $Y=116995
X10820 VSS: 2 VSS: 1807 2392 2391 2 NAND2X1 $T=179400 121440 1 180 $X=177380 $Y=121175
X10826 VSS: 2 VSS: 2396 520 2 BUFX2_HS $T=166980 129720 1 0 $X=166800 $Y=125275
X10827 VSS: 2 VSS: 2397 2396 2394 2 NOR2X4_HS $T=169740 129720 1 0 $X=169560 $Y=125275
X10829 VSS: 2 VSS: 2393 520 2394 2 NAND2X2 $T=177560 129720 0 180 $X=175080 $Y=125275
X10837 VSS: 2 VSS: 2398 1927 1516 2 NAND2X1_HS $T=167440 129720 0 0 $X=167260 $Y=129455
X10840 VSS: 2 VSS: 2399 538 2373 2 NAND2X2_HS $T=174340 129720 0 0 $X=174160 $Y=129455
X10842 VSS: 2 VSS: 2400 2654 2398 118 2 MX2X1_HS $T=182160 129720 1 180 $X=177840 $Y=129455
X10848 VSS: 2 VSS: 2395 2399 2401 2 NAND2X1 $T=168360 138000 0 180 $X=166340 $Y=133555
X10851 VSS: 2 VSS: 2402 538 2373 2 NOR2X2_HS $T=171120 138000 1 0 $X=170940 $Y=133555
X10854 VSS: 2 VSS: 2655 118 1812 2 NAND2X2_HS $T=178940 138000 1 0 $X=178760 $Y=133555
X10860 VSS: 2 VSS: 2406 2393 2403 2 NAND2X1 $T=167900 138000 1 180 $X=165880 $Y=137735
X10861 VSS: 2 VSS: 2403 2397 2 CLKINVX1 $T=169280 138000 1 180 $X=167720 $Y=137735
X10864 VSS: 2 VSS: 2401 2405 2 INVX1 $T=172040 138000 1 180 $X=170480 $Y=137735
X10865 VSS: 2 VSS: 2405 2402 2 BUFX2 $T=174340 138000 1 180 $X=171860 $Y=137735
X10869 VSS: 2 VSS: 2659 2404 2392 2658 2 OAI21X2_HS $T=177560 138000 0 0 $X=177380 $Y=137735
X10874 VSS: 2 VSS: 2144 2407 2147 2 NAND2X2_HS $T=168360 146280 0 180 $X=164960 $Y=141835
X10875 VSS: 2 VSS: 2407 2397 2402 2 NOR2X2_HS $T=168360 146280 1 0 $X=168180 $Y=141835
X10876 VSS: 2 VSS: 2408 2397 2402 2 NOR2X2_HS $T=174800 146280 0 180 $X=171400 $Y=141835
X10879 VSS: 2 VSS: 2664 291 2661 2 NOR2X2_HS $T=178940 146280 1 0 $X=178760 $Y=141835
X10885 VSS: 2 VSS: 2156 2397 2393 2399 2 OAI21X2_HS $T=174800 146280 1 180 $X=170020 $Y=146015
X10888 VSS: 2 VSS: 2409 2404 2664 2 NOR2X2_HS $T=177560 146280 0 0 $X=177380 $Y=146015
X10894 VSS: 2 VSS: 2145 2409 2410 2 NAND2X2_HS $T=176180 154560 0 180 $X=172780 $Y=150115
X10897 VSS: 2 VSS: 2413 2659 2412 2409 2 AOI21X2_HS $T=182160 154560 0 180 $X=177380 $Y=150115
X10901 VSS: 2 VSS: 2411 2156 2414 2408 2 AOI21X2_HS $T=167440 154560 0 0 $X=167260 $Y=154295
X10904 VSS: 2 VSS: 2157 2415 2416 2417 2 OAI21X2_HS $T=174340 154560 0 0 $X=174160 $Y=154295
X10909 VSS: 2 VSS: 2141 2414 2 CLKBUFX2 $T=168820 162840 0 180 $X=166340 $Y=158395
X10912 VSS: 2 VSS: 2154 2415 2418 2 NOR2X2_HS $T=174800 162840 0 180 $X=171400 $Y=158395
X10914 VSS: 2 VSS: 2417 2419 2 CLKINVX2 $T=176640 162840 1 0 $X=176460 $Y=158395
X10916 VSS: 2 VSS: 2419 2412 2 CLKBUFX2 $T=181240 162840 0 180 $X=178760 $Y=158395
X10922 VSS: 2 VSS: 2418 2163 2 CLKINVX2 $T=171120 162840 0 0 $X=170940 $Y=162575
X10925 VSS: 2 VSS: 2163 2410 2 CLKBUFX2_HS $T=177100 162840 1 180 $X=173700 $Y=162575
X10928 VSS: 2 VSS: 2412 2420 2670 2158 2 OAI21X2_HS $T=184460 162840 1 180 $X=179680 $Y=162575
X10935 VSS: 2 VSS: 2166 2419 2163 2155 2 AOI21X2_HS $T=171120 171120 0 180 $X=166340 $Y=166675
X10938 VSS: 2 VSS: 2422 2399 2 INVX1 $T=172500 171120 1 0 $X=172320 $Y=166675
X10941 VSS: 2 VSS: 2410 2420 2421 2 NOR2X2_HS $T=179860 171120 0 180 $X=176460 $Y=166675
X10946 VSS: 2 VSS: 2159 2424 2 CLKINVX2 $T=166060 171120 1 180 $X=164500 $Y=170855
X10949 VSS: 2 VSS: 2425 2414 2 BUFX2 $T=168360 171120 0 0 $X=168180 $Y=170855
X10951 VSS: 2 VSS: 2424 2421 2 CLKBUFX2 $T=173880 171120 1 180 $X=171400 $Y=170855
X10954 VSS: 2 VSS: 2421 2423 301 2 NOR2X1_HS $T=176180 171120 0 0 $X=176000 $Y=170855
X10960 VSS: 2 VSS: 2414 2192 2428 2426 2 OAI21X2_HS $T=170660 179400 0 180 $X=165880 $Y=174955
X10963 VSS: 2 VSS: 301 2427 2 BUFX8_HS $T=180320 179400 0 180 $X=174620 $Y=174955
X10971 VSS: 2 VSS: 2429 2422 2425 2401 2 AOI21X2_HS $T=174340 179400 1 180 $X=169560 $Y=179135
X10974 VSS: 2 VSS: 2677 2678 2 BUFX16_HS $T=186760 179400 1 180 $X=176460 $Y=179135
X10978 VSS: 2 VSS: 2431 2401 2147 2 NAND2X1 $T=168360 187680 0 180 $X=166340 $Y=183235
X10982 VSS: 2 VSS: 2678 1822 2430 2 AND2X2_HS $T=179400 187680 1 0 $X=179220 $Y=183235
X10986 VSS: 2 VSS: 2436 1791 2432 2 NAND2X2_HS $T=164220 187680 0 0 $X=164040 $Y=187415
X10987 VSS: 2 VSS: 2432 2406 2434 2435 2 OAI21X1_HS $T=170200 187680 1 180 $X=167260 $Y=187415
X10990 VSS: 2 VSS: 2433 569 2436 2 NAND2X2_HS $T=172960 187680 0 0 $X=172780 $Y=187415
X10994 VSS: 2 VSS: 2430 2681 2433 118 2 MX2X1_HS $T=183540 187680 1 180 $X=179220 $Y=187415
X10999 VSS: 2 VSS: 2434 2406 2435 2 NAND2X2_HS $T=165600 195960 1 0 $X=165420 $Y=191515
X11008 VSS: 2 VSS: 2435 2431 2429 2208 2 OAI21X2_HS $T=169280 195960 1 180 $X=164500 $Y=195695
X11011 VSS: 2 VSS: 361 2438 2 CLKBUFX4 $T=176640 195960 1 180 $X=173700 $Y=195695
X11013 VSS: 2 VSS: 191 2439 2 BUFX8 $T=177100 195960 0 0 $X=176920 $Y=195695
X11017 VSS: 2 VSS: 2147 2426 2440 2 NOR2X4 $T=169280 204240 0 180 $X=164960 $Y=199795
X11020 VSS: 2 VSS: 2441 2426 2 INVX1 $T=172960 204240 0 180 $X=171400 $Y=199795
X11027 VSS: 2 VSS: 2186 2440 2 CLKBUFX2 $T=166520 204240 1 180 $X=164040 $Y=203975
X11030 VSS: 2 VSS: 2444 2440 2 CLKINVX1 $T=167900 204240 0 0 $X=167720 $Y=203975
X11031 VSS: 2 VSS: 2440 170 2442 2 NOR2X2_HS $T=172500 204240 1 180 $X=169100 $Y=203975
X11034 VSS: 2 VSS: 2426 2443 2689 2 NOR2X4_HS $T=177100 204240 0 0 $X=176920 $Y=203975
X11041 VSS: 2 VSS: 2197 2445 2441 2 NAND2X1 $T=168360 212520 0 180 $X=166340 $Y=208075
X11045 VSS: 2 VSS: 2445 2428 2 BUFX2_HS $T=176180 212520 0 180 $X=173240 $Y=208075
X11054 VSS: 2 VSS: 2446 2192 2444 2 NAND2X1 $T=170200 212520 1 180 $X=168180 $Y=212255
X11062 VSS: 2 VSS: 2449 813 2447 2 AND2X1_HS $T=166980 220800 0 180 $X=164040 $Y=216355
X11064 VSS: 2 VSS: 2192 170 2442 2 NAND2X4_HS $T=172960 220800 0 180 $X=167720 $Y=216355
X11067 VSS: 2 VSS: 2447 2448 1552 118 2 MX2X1 $T=178020 220800 0 180 $X=174160 $Y=216355
X11068 VSS: 2 VSS: 2694 1552 2 BUFX4_HS $T=178020 220800 1 0 $X=177840 $Y=216355
X11073 VSS: 2 VSS: 2696 2449 2 BUFX16_HS $T=174340 220800 0 0 $X=174160 $Y=220535
X11080 VSS: 2 VSS: 2453 2451 2452 2 NAND2X1 $T=175260 229080 0 180 $X=173240 $Y=224635
X11081 VSS: 2 VSS: 2452 118 2 INVX2 $T=176640 229080 0 180 $X=175080 $Y=224635
X11085 VSS: 2 VSS: 2689 2700 2699 2698 2 OAI21X2_HS $T=184460 229080 0 180 $X=179680 $Y=224635
X11089 VSS: 2 VSS: 2455 2454 2205 2 NAND2X2_HS $T=169280 229080 1 180 $X=165880 $Y=228815
X11090 VSS: 2 VSS: 2456 118 2200 2 NAND2X2_HS $T=169280 229080 0 0 $X=169100 $Y=228815
X11092 VSS: 2 VSS: 2457 2453 2456 2 NAND2X4_HS $T=172960 229080 0 0 $X=172780 $Y=228815
X11095 VSS: 2 VSS: 2699 2701 2698 2 NAND2X2_HS $T=183540 229080 1 180 $X=180140 $Y=228815
X11100 VSS: 2 VSS: 2458 2446 2208 2 NAND2X2 $T=166980 237360 0 180 $X=164500 $Y=232915
X11102 VSS: 2 VSS: 2459 2457 2 BUFX16_HS $T=180780 237360 0 180 $X=170480 $Y=232915
X11107 VSS: 2 VSS: 2460 2446 1791 2208 2458 2 OAI211X1_HS $T=168360 237360 1 180 $X=164960 $Y=237095
X11108 VSS: 2 VSS: 2461 1838 2460 2 NAND2X1_HS $T=168360 237360 0 0 $X=168180 $Y=237095
X11116 VSS: 2 VSS: 2464 2463 118 2462 2215 2 OAI22X2_HS $T=166060 245640 1 0 $X=165880 $Y=241195
X11117 VSS: 2 VSS: 2462 2461 2 INVX1_HS $T=173420 245640 0 180 $X=171400 $Y=241195
X11121 VSS: 2 VSS: 1881 2706 1641 2 AND2X1 $T=182160 245640 0 180 $X=179680 $Y=241195
X11127 VSS: 2 VSS: 2463 2465 2 INVX2 $T=167900 245640 1 180 $X=166340 $Y=245375
X11129 VSS: 2 VSS: 2466 2464 2 BUFX16_HS $T=169740 245640 0 0 $X=169560 $Y=245375
X11135 VSS: 2 VSS: 2348 101 2 BUFX8_HS $T=170660 253920 0 180 $X=164960 $Y=249475
X11143 VSS: 2 VSS: 1889 118 2467 2 OR2X1 $T=170200 253920 0 0 $X=170020 $Y=253655
X11153 VSS: 2 VSS: 2470 118 2221 2 NAND2X2_HS $T=169740 262200 0 180 $X=166340 $Y=257755
X11155 VSS: 2 VSS: 2468 2469 2470 2 NAND2X4_HS $T=178480 262200 0 180 $X=173240 $Y=257755
X11156 VSS: 2 VSS: 2714 2468 2 BUFX16_HS $T=178480 262200 1 0 $X=178300 $Y=257755
X11161 VSS: 2 VSS: 2442 2472 2471 2 NAND2X4_HS $T=173880 262200 1 180 $X=168640 $Y=261935
X11167 VSS: 2 VSS: 1570 91 2223 2 NOR2X1_HS $T=166980 270480 0 180 $X=164500 $Y=266035
X11170 VSS: 2 VSS: 2471 2474 2473 2 NAND2X2_HS $T=174800 270480 0 180 $X=171400 $Y=266035
X11173 VSS: 2 VSS: 2473 2475 2 INVX2 $T=178940 270480 0 180 $X=177380 $Y=266035
X11178 VSS: 2 VSS: 2476 635 2 INVX2 $T=166520 270480 0 0 $X=166340 $Y=270215
X11180 VSS: 2 VSS: 2472 2476 2477 2 NAND2X2_HS $T=169740 270480 0 0 $X=169560 $Y=270215
X11182 VSS: 2 VSS: 2477 2474 2 INVX1_HS $T=175720 270480 1 180 $X=173700 $Y=270215
X11190 VSS: 2 VSS: 2474 2349 1624 101 2478 2 AOI22X2_HS $T=169740 278760 1 0 $X=169560 $Y=274315
X11197 VSS: 2 VSS: 95 2480 2232 2 NAND2X2 $T=168820 278760 1 180 $X=166340 $Y=278495
X11200 VSS: 2 VSS: 2479 415 853 2 NAND2X4_HS $T=176180 278760 0 0 $X=176000 $Y=278495
X11206 VSS: 2 VSS: 2480 2245 2 CLKBUFX2 $T=170660 287040 0 180 $X=168180 $Y=282595
X11209 VSS: 2 VSS: 2481 2439 2 CLKBUFX2 $T=177100 287040 0 180 $X=174620 $Y=282595
X11218 VSS: 2 VSS: 2234 2482 2481 2 NAND2X2_HS $T=175720 287040 1 180 $X=172320 $Y=286775
X11221 VSS: 2 VSS: 2709 617 2 BUFX4_HS $T=180320 287040 0 0 $X=180140 $Y=286775
X11226 VSS: 2 VSS: 2233 2483 2 CLKINVX4 $T=167440 295320 1 0 $X=167260 $Y=290875
X11230 VSS: 2 VSS: 2484 2439 2 CLKBUFX2 $T=178480 295320 0 180 $X=176000 $Y=290875
X11236 VSS: 2 VSS: 2483 2485 2 BUFX2_HS $T=166520 295320 0 0 $X=166340 $Y=295055
X11239 VSS: 2 VSS: 2485 2484 2482 2 NOR2X2_HS $T=178020 295320 1 180 $X=174620 $Y=295055
X11247 VSS: 2 VSS: 2241 2485 2486 2 NOR2X2_HS $T=166980 303600 1 0 $X=166800 $Y=299155
X11249 VSS: 2 VSS: 2487 2438 2 CLKBUFX4 $T=176640 303600 0 180 $X=173700 $Y=299155
X11252 VSS: 2 VSS: 2729 2486 2 CLKINVX1 $T=179400 303600 1 0 $X=179220 $Y=299155
X11258 VSS: 2 VSS: 2242 2487 2489 2 NOR2X4_HS $T=165600 303600 0 0 $X=165420 $Y=303335
X11261 VSS: 2 VSS: 2244 2234 2488 2486 2 OAI21X2_HS $T=172040 303600 0 0 $X=171860 $Y=303335
X11268 VSS: 2 VSS: 2240 2246 2490 2 NOR2X1_HS $T=166980 311880 0 180 $X=164500 $Y=307435
X11271 VSS: 2 VSS: 2245 2489 2487 2 NAND2X2_HS $T=171580 311880 1 0 $X=171400 $Y=307435
X11275 VSS: 2 VSS: 204 2737 2 BUFX8 $T=183080 311880 0 180 $X=177840 $Y=307435
X11280 VSS: 2 VSS: 2489 2492 2491 2493 2 OAI21X2_HS $T=170200 311880 0 0 $X=170020 $Y=311615
X11282 VSS: 2 VSS: 2491 2494 2493 2 NAND2X2_HS $T=176640 311880 0 0 $X=176460 $Y=311615
X11287 VSS: 2 VSS: 2498 101 1624 2349 2495 2 AOI22X2_HS $T=171120 320160 0 180 $X=165420 $Y=315715
X11291 VSS: 2 VSS: 2493 639 2496 2497 2269 2 OAI22X2_HS $T=176180 320160 1 0 $X=176000 $Y=315715
X11297 VSS: 2 VSS: 2492 635 2 INVX4 $T=173420 320160 1 180 $X=170940 $Y=319895
X11300 VSS: 2 VSS: 2494 635 2 INVX4 $T=176180 320160 0 0 $X=176000 $Y=319895
X11308 VSS: 2 VSS: 2499 635 2503 2502 2 OAI21X2_HS $T=173420 328440 0 180 $X=168640 $Y=323995
X11310 VSS: 2 VSS: 2500 2501 2 CLKINVX1_HS $T=177100 328440 1 0 $X=176920 $Y=323995
X11317 VSS: 2 VSS: 2503 635 2502 2 NAND2X2_HS $T=171580 328440 0 0 $X=171400 $Y=328175
X11319 VSS: 2 VSS: 2250 404 2 CLKBUFX2 $T=180780 328440 1 180 $X=178300 $Y=328175
X11326 VSS: 2 VSS: 2502 101 1624 2349 2504 2 AOI22X2_HS $T=167900 336720 1 0 $X=167720 $Y=332275
X11333 VSS: 2 VSS: 2256 1106 2507 2505 2 OAI21X2_HS $T=165140 336720 0 0 $X=164960 $Y=336455
X11336 VSS: 2 VSS: 2505 302 2 CLKINVX4_HS $T=171120 336720 0 0 $X=170940 $Y=336455
X11339 VSS: 2 VSS: 2258 2506 2736 2 NOR2X4_HS $T=178940 336720 0 0 $X=178760 $Y=336455
X11345 VSS: 2 VSS: 2508 2509 629 2 NOR2X2_HS $T=173420 345000 0 180 $X=170020 $Y=340555
X11349 VSS: 2 VSS: 2744 2510 2508 2 NAND2X1_HS $T=178480 345000 1 0 $X=178300 $Y=340555
X11353 VSS: 2 VSS: 2262 1106 2507 2511 2 OAI21X2_HS $T=164220 345000 0 0 $X=164040 $Y=344735
X11355 VSS: 2 VSS: 2509 1306 1606 2 XOR2X1_HS $T=176640 345000 1 180 $X=172320 $Y=344735
X11357 VSS: 2 VSS: 2510 2512 2513 2 NOR2X1_HS $T=180780 345000 1 180 $X=178300 $Y=344735
X11364 VSS: 2 VSS: 2507 639 2514 2 OR2X1 $T=176180 353280 1 0 $X=176000 $Y=348835
X11374 VSS: 2 VSS: 2482 2515 2516 2 NAND2X2_HS $T=177560 353280 1 180 $X=174160 $Y=353015
X11380 VSS: 2 VSS: 2263 2349 1624 101 1357 2 AOI22X2_HS $T=168820 361560 1 0 $X=168640 $Y=357115
X11388 VSS: 2 VSS: 2496 472 2 INVX1 $T=171120 361560 0 0 $X=170940 $Y=361295
X11395 VSS: 2 VSS: 2267 2268 2518 2 NAND2X2_HS $T=164680 369840 1 0 $X=164500 $Y=365395
X11401 VSS: 2 VSS: 2753 2517 2756 2 NOR2X2_HS $T=178480 369840 1 0 $X=178300 $Y=365395
X11406 VSS: 2 VSS: 2518 2519 2277 2269 2 OAI21X2_HS $T=168820 369840 1 180 $X=164040 $Y=369575
X11410 VSS: 2 VSS: 2512 2273 2265 2 XOR2X1_HS $T=172040 369840 0 0 $X=171860 $Y=369575
X11412 VSS: 2 VSS: 2756 635 2 INVX4 $T=179860 369840 0 0 $X=179680 $Y=369575
X11418 VSS: 2 VSS: 2521 2269 2 INVX2 $T=172500 378120 0 180 $X=170940 $Y=373675
X11422 VSS: 2 VSS: 2522 639 2 INVX2 $T=175720 378120 1 0 $X=175540 $Y=373675
X11429 VSS: 2 VSS: 2520 2521 2523 2 NAND2X2_HS $T=171120 378120 1 180 $X=167720 $Y=377855
X11433 VSS: 2 VSS: 2523 2519 2 INVX2_HS $T=178480 378120 1 180 $X=176000 $Y=377855
X11439 VSS: 2 VSS: 2278 2277 2 CLKINVX2 $T=166060 386400 0 180 $X=164500 $Y=381955
X11444 VSS: 2 VSS: 472 107 112 2 CLKAND2X2 $T=175260 386400 0 180 $X=172780 $Y=381955
X11451 VSS: 2 VSS: 449 107 2525 2 CLKAND2X2 $T=170660 386400 1 180 $X=168180 $Y=386135
X11455 VSS: 2 VSS: 2763 2524 2762 2 NOR2X2_HS $T=178940 386400 0 0 $X=178760 $Y=386135
X11461 VSS: 2 VSS: 241 107 109 2 CLKAND2X2 $T=171120 394680 0 180 $X=168640 $Y=390235
X11465 VSS: 2 VSS: 109 1364 2763 2 AND2X1_HS $T=182160 394680 0 180 $X=179220 $Y=390235
X11470 VSS: 2 VSS: 262 107 111 2 CLKAND2X2 $T=170200 394680 1 180 $X=167720 $Y=394415
X11474 VSS: 2 VSS: 673 107 110 2 CLKAND2X2 $T=178020 394680 0 0 $X=177840 $Y=394415
X11483 VSS: 2 VSS: 674 107 2526 2 CLKAND2X2 $T=181700 402960 0 180 $X=179220 $Y=398515
X11489 VSS: 2 VSS: 2529 2528 2527 2525 2 NOR3X2_HS $T=168360 402960 0 0 $X=168180 $Y=402695
X11493 VSS: 2 VSS: 2528 2526 2 INVX2_HS $T=178480 402960 1 180 $X=176000 $Y=402695
X11501 VSS: 2 VSS: 2293 2530 105 2529 2 NAND3X2_HS $T=168820 411240 1 0 $X=168640 $Y=406795
X11504 VSS: 2 VSS: 1380 1364 2769 2 NAND2X4_HS $T=184000 411240 0 180 $X=178760 $Y=406795
X11513 VSS: 2 VSS: 2532 2531 2 INVX4_HS $T=178020 411240 0 0 $X=177840 $Y=410975
X11518 VSS: 2 VSS: 2535 1670 2533 2 NAND2X4_HS $T=169280 419520 1 0 $X=169100 $Y=415075
X11521 VSS: 2 VSS: 2533 2534 2532 2 NOR2X4_HS $T=178940 419520 1 0 $X=178760 $Y=415075
X11528 VSS: 2 VSS: 2530 2536 2535 2 NOR2X2_HS $T=169280 419520 0 0 $X=169100 $Y=419255
X11531 VSS: 2 VSS: 1664 2534 2532 2 NOR2X4_HS $T=178020 419520 0 0 $X=177840 $Y=419255
X11536 VSS: 2 VSS: 887 2536 2535 2 NOR2X4_HS $T=169740 427800 1 0 $X=169560 $Y=423355
X11545 VSS: 2 VSS: 1972 2537 2 INVX4_HS $T=179860 427800 1 180 $X=176460 $Y=427535
X11553 VSS: 2 VSS: 1681 2541 2539 2540 2538 2 AOI22X2_HS $T=172040 436080 1 0 $X=171860 $Y=431635
X11563 VSS: 2 VSS: 2299 2538 2543 2542 2541 2 AOI22X1_HS $T=177560 436080 0 0 $X=177380 $Y=435815
X11569 VSS: 2 VSS: 2545 2544 2 BUFX4_HS $T=168820 444360 1 0 $X=168640 $Y=439915
X11578 VSS: 2 VSS: 2301 2546 2542 2543 2545 2 AOI22X2_HS $T=173880 444360 1 180 $X=168180 $Y=444095
X11587 VSS: 2 VSS: 1672 2546 2539 2540 2545 2 AOI22X2_HS $T=173420 452640 0 180 $X=167720 $Y=448195
X11598 VSS: 2 VSS: 1678 7528 1893 2547 2 DFFX1_HS $T=174800 452640 0 0 $X=174620 $Y=452375
X11607 VSS: 2 VSS: 2549 2306 2548 2 NAND2X1 $T=174340 460920 1 0 $X=174160 $Y=456475
X11617 VSS: 2 VSS: 1984 2551 2550 2553 2552 2 NAND4X1 $T=178480 460920 1 180 $X=175540 $Y=460655
X11627 VSS: 2 VSS: 2553 2554 2555 2564 1156 2 AOI22X1 $T=178940 469200 1 0 $X=178760 $Y=464755
X11632 VSS: 2 VSS: 2556 2316 2557 2 NAND2X1 $T=165600 469200 0 0 $X=165420 $Y=468935
X11646 VSS: 2 VSS: 2783 2313 2782 2 NAND2X1 $T=179860 477480 1 0 $X=179680 $Y=473035
X11653 VSS: 2 VSS: 2552 1981 2320 2558 914 2 AOI22X1 $T=172040 477480 0 0 $X=171860 $Y=477215
X11661 VSS: 2 VSS: 1999 2561 2562 2560 2559 2 NAND4X1 $T=175260 485760 0 180 $X=172320 $Y=481315
X11670 VSS: 2 VSS: 2560 2563 2555 2564 1421 2 AOI22X1 $T=175720 485760 0 0 $X=175540 $Y=485495
X11680 VSS: 2 VSS: 2561 2565 2317 2343 1163 2 AOI22X1 $T=174340 494040 1 0 $X=174160 $Y=489595
X11690 VSS: 2 VSS: 2792 2318 2791 2 NAND2X1 $T=179860 494040 0 0 $X=179680 $Y=493775
X11697 VSS: 2 VSS: 2559 1983 2320 2558 1712 2 AOI22X1 $T=172960 502320 0 180 $X=170020 $Y=497875
X11709 VSS: 2 VSS: 2567 1721 2792 2568 2 AOI21X1 $T=182160 502320 1 180 $X=179680 $Y=502055
X11716 VSS: 2 VSS: 2569 1182 2556 2568 2 AOI21X1 $T=180320 510600 0 180 $X=177840 $Y=506155
X11722 VSS: 2 VSS: 1168 7529 2018 2570 2 DFFX1_HS $T=168360 510600 0 0 $X=168180 $Y=510335
X11725 VSS: 2 VSS: 1698 7530 1893 2571 2 DFFX1_HS $T=180320 510600 0 0 $X=180140 $Y=510335
X11729 VSS: 2 VSS: 917 7531 2018 2322 2 DFFX1_HS $T=166520 518880 1 0 $X=166340 $Y=514435
X11730 VSS: 2 VSS: 1721 7532 1561 2570 2 DFFX1_HS $T=175720 518880 1 0 $X=175540 $Y=514435
X11734 VSS: 2 VSS: 706 7533 1914 2322 2 DFFX1_HS $T=165140 518880 0 0 $X=164960 $Y=518615
X11737 VSS: 2 VSS: 1428 7534 1561 2571 2 DFFX1_HS $T=175720 518880 0 0 $X=175540 $Y=518615
X11743 VSS: 2 VSS: 1182 7535 1914 2570 2 DFFX1_HS $T=174340 527160 1 0 $X=174160 $Y=522715
X11750 VSS: 2 VSS: 1438 7536 1561 2322 2 DFFX1_HS $T=167440 527160 0 0 $X=167260 $Y=526895
X11752 VSS: 2 VSS: 1178 7537 2015 2322 2 DFFX1_HS $T=177100 527160 0 0 $X=176920 $Y=526895
X11761 VSS: 2 VSS: 2572 2797 2335 2798 2567 2 NAND4X1 $T=182620 535440 0 180 $X=179680 $Y=530995
X11768 VSS: 2 VSS: 2576 2573 2574 2575 2569 2 NAND4X1 $T=180320 535440 1 180 $X=177380 $Y=535175
X11775 VSS: 2 VSS: 1423 7538 1893 2325 2 DFFX1_HS $T=168360 543720 1 0 $X=168180 $Y=539275
X11777 VSS: 2 VSS: 1156 7539 2018 2578 2 DFFX1_HS $T=179400 543720 1 0 $X=179220 $Y=539275
X11783 VSS: 2 VSS: 1422 7540 1893 2577 2 DFFX1_HS $T=166060 543720 0 0 $X=165880 $Y=543455
X11785 VSS: 2 VSS: 1421 7541 1893 2578 2 DFFX1_HS $T=178940 543720 0 0 $X=178760 $Y=543455
X11791 VSS: 2 VSS: 1157 7542 2018 2577 2 DFFX1_HS $T=167900 552000 1 0 $X=167720 $Y=547555
X11797 VSS: 2 VSS: 1712 7543 1893 2579 2 DFFX1_HS $T=166520 552000 0 0 $X=166340 $Y=551735
X11799 VSS: 2 VSS: 914 7544 2018 2579 2 DFFX1_HS $T=176180 552000 0 0 $X=176000 $Y=551735
X11814 VSS: 2 VSS: 958 7545 2015 2579 2 DFFX1_HS $T=169740 560280 0 0 $X=169560 $Y=560015
X11821 VSS: 2 VSS: 957 7546 1914 2579 2 DFFX1_HS $T=172960 568560 1 0 $X=172780 $Y=564115
X11829 VSS: 2 VSS: 1457 7547 2015 2577 2 DFFX1_HS $T=168360 568560 0 0 $X=168180 $Y=568295
X11831 VSS: 2 VSS: 1189 7548 2015 2802 2 DFFX1_HS $T=179400 568560 0 0 $X=179220 $Y=568295
X11839 VSS: 2 VSS: 2581 2580 2317 2343 1189 2 AOI22X1 $T=177100 576840 1 0 $X=176920 $Y=572395
X11847 VSS: 2 VSS: 2328 2581 2582 2584 2583 2 NAND4X1 $T=172500 576840 1 180 $X=169560 $Y=576575
X11856 VSS: 2 VSS: 2583 2035 2320 2558 958 2 AOI22X1 $T=167900 585120 1 0 $X=167720 $Y=580675
X11865 VSS: 2 VSS: 1465 7549 1561 2577 2 DFFX1_HS $T=165600 585120 0 0 $X=165420 $Y=584855
X11867 VSS: 2 VSS: 1458 7550 2015 2578 2 DFFX1_HS $T=178480 585120 0 0 $X=178300 $Y=584855
X11874 VSS: 2 VSS: 2586 2585 2317 2343 1192 2 AOI22X1 $T=177560 593400 1 0 $X=177380 $Y=588955
X11880 VSS: 2 VSS: 1731 7551 1561 2323 2 DFFX1_HS $T=167900 593400 0 0 $X=167720 $Y=593135
X11886 VSS: 2 VSS: 1204 7552 1914 2577 2 DFFX1_HS $T=165140 601680 1 0 $X=164960 $Y=597235
X11890 VSS: 2 VSS: 1466 7553 1561 2578 2 DFFX1_HS $T=177560 601680 1 0 $X=177380 $Y=597235
X11895 VSS: 2 VSS: 1715 7554 1561 2579 2 DFFX1_HS $T=167440 601680 0 0 $X=167260 $Y=601415
X11902 VSS: 2 VSS: 2334 2587 2590 2588 2589 2 NAND4X1 $T=171580 609960 0 180 $X=168640 $Y=605515
X11911 VSS: 2 VSS: 2589 2047 2320 2558 1715 2 AOI22X1 $T=169280 609960 0 0 $X=169100 $Y=609695
X11915 VSS: 2 VSS: 2046 7555 1561 2547 2 DFFX1_HS $T=180320 609960 0 0 $X=180140 $Y=609695
X11920 VSS: 2 VSS: 2574 2592 2339 1738 2 NOR3X1 $T=166520 618240 1 0 $X=166340 $Y=613795
X11924 VSS: 2 VSS: 2592 2586 2594 2593 2591 2 NAND4X1 $T=179860 618240 0 180 $X=176920 $Y=613795
X11933 VSS: 2 VSS: 2591 2048 2320 2558 957 2 AOI22X1 $T=170200 618240 0 0 $X=170020 $Y=617975
X11942 VSS: 2 VSS: 1212 2595 2598 2597 2596 2 AOI22X2_HS $T=173880 626520 1 0 $X=173700 $Y=622075
X11966 VSS: 2 VSS: 971 2596 2602 2601 2595 2 AOI22X2 $T=183080 634800 1 180 $X=178300 $Y=634535
X11972 VSS: 2 VSS: 1742 2602 2601 2544 2600 2 AOI22X2_HS $T=170660 643080 1 0 $X=170480 $Y=638635
X11986 VSS: 2 VSS: 2605 2604 538 2 NAND2X2 $T=190440 13800 1 0 $X=190260 $Y=9355
X11998 VSS: 2 VSS: 2606 2607 2 CLKBUFX4 $T=193200 22080 1 0 $X=193020 $Y=17635
X12001 VSS: 2 VSS: 2609 addr_i[2] addr_i[3] addr_i[4] 2 NAND3X1 $T=184000 22080 1 180 $X=181520 $Y=21815
X12004 VSS: 2 VSS: 2610 2345 2609 2 NOR2X1 $T=186300 22080 0 0 $X=186120 $Y=21815
X12007 VSS: 2 VSS: 2607 addr_i[4] 2345 addr_i[2] 2608 2 NOR4X1 $T=192740 22080 0 0 $X=192560 $Y=21815
X12012 VSS: 2 VSS: 2603 2610 2 CLKBUFX2 $T=188140 30360 1 0 $X=187960 $Y=25915
X12015 VSS: 2 VSS: 2608 addr_i[3] 2 INVX1 $T=194120 30360 0 180 $X=192560 $Y=25915
X12018 VSS: 2 VSS: 2621 addr_i[4] 2 INVX1 $T=196420 30360 1 0 $X=196240 $Y=25915
X12023 VSS: 2 VSS: 2611 addr_i[2] 2608 addr_i[4] 2 NOR3X1 $T=193660 30360 1 180 $X=191180 $Y=30095
X12031 VSS: 2 VSS: 2614 2613 2611 2 NAND2X1 $T=194120 38640 0 180 $X=192100 $Y=34195
X12033 VSS: 2 VSS: 2613 1634 2 INVX1 $T=197340 38640 0 180 $X=195780 $Y=34195
X12043 VSS: 2 VSS: 2615 addr_i[5] addr_i[6] 2 NOR2X1 $T=190900 46920 1 0 $X=190720 $Y=42475
X12046 VSS: 2 VSS: 2616 2614 addr_i[5] addr_i[6] 2 NOR3X1 $T=197800 46920 0 180 $X=195320 $Y=42475
X12051 VSS: 2 VSS: 370 2617 2 BUFX8_HS $T=194580 46920 1 180 $X=188880 $Y=46655
X12057 VSS: 2 VSS: 1079 2617 2 CLKBUFX4 $T=192740 55200 0 180 $X=189800 $Y=50755
X12059 VSS: 2 VSS: 2619 addr_i[6] 2 INVX1 $T=196420 55200 1 0 $X=196240 $Y=50755
X12072 VSS: 2 VSS: 2622 addr_i[2] addr_i[3] 2613 addr_i[4] 2 NAND4X1 $T=196420 63480 1 180 $X=193480 $Y=63215
X12076 VSS: 2 VSS: 2623 addr_i[2] addr_i[3] addr_i[4] 2 NOR3X1 $T=192740 71760 0 180 $X=190260 $Y=67315
X12082 VSS: 2 VSS: 2625 2622 addr_i[5] addr_i[6] 2 NOR3X1 $T=194580 71760 0 0 $X=194400 $Y=71495
X12090 VSS: 2 VSS: 2630 635 2 INVX4 $T=183080 88320 0 180 $X=180600 $Y=83875
X12093 VSS: 2 VSS: 2357 2629 2 BUFX8_HS $T=189980 88320 0 180 $X=184280 $Y=83875
X12097 VSS: 2 VSS: 2796 2625 2 BUFX4_HS $T=195960 88320 1 0 $X=195780 $Y=83875
X12101 VSS: 2 VSS: 2634 2631 2 INVX2_HS $T=192280 88320 1 180 $X=189800 $Y=88055
X12102 VSS: 2 VSS: 2631 2349 1624 2348 2632 2 AOI22X2_HS $T=192280 88320 0 0 $X=192100 $Y=88055
X12103 VSS: 2 VSS: 2638 635 2 INVX4 $T=185380 96600 1 0 $X=185200 $Y=92155
X12106 VSS: 2 VSS: 2637 2638 2634 2 NAND2X2 $T=189060 96600 1 0 $X=188880 $Y=92155
X12110 VSS: 2 VSS: 2640 635 2 CLKINVX2 $T=186760 96600 1 180 $X=185200 $Y=96335
X12112 VSS: 2 VSS: 2394 2640 2637 2634 2 OAI21X2_HS $T=188600 96600 0 0 $X=188420 $Y=96335
X12115 VSS: 2 VSS: 2838 2348 1624 2349 2839 2 AOI22X2_HS $T=201480 96600 1 180 $X=195780 $Y=96335
X12120 VSS: 2 VSS: 2642 2604 2605 538 2 OAI21X2 $T=197340 104880 0 180 $X=193480 $Y=100435
X12125 VSS: 2 VSS: 2646 118 2644 2 NAND2X2_HS $T=180780 113160 1 0 $X=180600 $Y=108715
X12129 VSS: 2 VSS: 2645 2647 2646 2 NAND2X2_HS $T=190440 113160 0 180 $X=187040 $Y=108715
X12130 VSS: 2 VSS: 2846 2645 2 BUFX16_HS $T=190440 113160 1 0 $X=190260 $Y=108715
X12135 VSS: 2 VSS: 2649 2651 2390 2 NAND2X2_HS $T=185380 121440 0 180 $X=181980 $Y=116995
X12138 VSS: 2 VSS: 2652 1229 2 CLKBUFX2 $T=195040 121440 0 180 $X=192560 $Y=116995
X12141 VSS: 2 VSS: 2391 2404 2 CLKINVX1 $T=183080 121440 1 180 $X=181520 $Y=121175
X12144 VSS: 2 VSS: 2404 2652 2650 2 NOR2X4_HS $T=185380 121440 0 0 $X=185200 $Y=121175
X12147 VSS: 2 VSS: 2392 2652 2650 2 NAND2X2 $T=193200 121440 0 0 $X=193020 $Y=121175
X12151 VSS: 2 VSS: 2627 2653 2 BUFX16_HS $T=195500 129720 0 180 $X=185200 $Y=125275
X12156 VSS: 2 VSS: 2653 1822 2400 2 AND2X1_HS $T=188600 129720 0 0 $X=188420 $Y=129455
X12159 VSS: 2 VSS: 2853 2632 520 2 NOR2X4_HS $T=195960 129720 0 0 $X=195780 $Y=129455
X12163 VSS: 2 VSS: 2657 2656 2655 2 NAND2X2_HS $T=193200 138000 0 180 $X=189800 $Y=133555
X12167 VSS: 2 VSS: 2660 635 2 INVX4 $T=189060 138000 1 180 $X=186580 $Y=137735
X12169 VSS: 2 VSS: 2860 2657 2 BUFX16_HS $T=190900 138000 0 0 $X=190720 $Y=137735
X12172 VSS: 2 VSS: 2658 291 2661 2 NAND2X2 $T=189980 146280 0 180 $X=187500 $Y=141835
X12174 VSS: 2 VSS: 2661 2660 2663 2662 2 OAI21X2_HS $T=193660 146280 1 0 $X=193480 $Y=141835
X12177 VSS: 2 VSS: 2415 2664 2 BUFX2 $T=183080 146280 0 0 $X=182900 $Y=146015
X12179 VSS: 2 VSS: 291 2665 2 BUFX4_HS $T=192740 146280 1 180 $X=188880 $Y=146015
X12183 VSS: 2 VSS: 2416 2658 2 CLKBUFX2 $T=188140 154560 0 180 $X=185660 $Y=150115
X12188 VSS: 2 VSS: 2863 2349 1624 2348 2864 2 AOI22X2_HS $T=200560 154560 0 180 $X=194860 $Y=150115
X12190 VSS: 2 VSS: 2454 2416 2667 2 NAND2X1 $T=181240 154560 0 0 $X=181060 $Y=154295
X12192 VSS: 2 VSS: 2667 2415 2 CLKINVX1 $T=184920 154560 1 180 $X=183360 $Y=154295
X12195 VSS: 2 VSS: 2666 635 2668 2 NAND2X2_HS $T=187680 154560 0 0 $X=187500 $Y=154295
X12198 VSS: 2 VSS: 2669 635 2666 2668 2 OAI21X2_HS $T=192280 154560 0 0 $X=192100 $Y=154295
X12200 VSS: 2 VSS: 1825 2672 2671 2 NAND2X1 $T=186760 162840 0 180 $X=184740 $Y=158395
X12203 VSS: 2 VSS: 2672 2670 2 BUFX2 $T=191820 162840 0 180 $X=189340 $Y=158395
X12206 VSS: 2 VSS: 2670 292 2669 2 NAND2X2 $T=196880 162840 0 180 $X=194400 $Y=158395
X12208 VSS: 2 VSS: 2671 2673 2 INVX1 $T=188140 162840 0 0 $X=187960 $Y=162575
X12211 VSS: 2 VSS: 2420 292 2669 2 NOR2X4_HS $T=192280 162840 0 0 $X=192100 $Y=162575
X12215 VSS: 2 VSS: 2673 2420 2 CLKBUFX2 $T=186760 171120 1 0 $X=186580 $Y=166675
X12220 VSS: 2 VSS: 2158 301 2423 2 NAND2X2_HS $T=182620 171120 0 0 $X=182440 $Y=170855
X12224 VSS: 2 VSS: 2674 2348 1624 2349 2675 2 AOI22X2_HS $T=191820 171120 0 0 $X=191640 $Y=170855
X12226 VSS: 2 VSS: 2423 635 2676 2 XOR2X1_HS $T=188600 179400 0 180 $X=184280 $Y=174955
X12229 VSS: 2 VSS: 2676 2674 2 INVX1_HS $T=194580 179400 0 180 $X=192560 $Y=174955
X12233 VSS: 2 VSS: 2679 2621 1835 2 OR2X1 $T=192280 179400 0 0 $X=192100 $Y=179135
X12238 VSS: 2 VSS: 2680 2619 1835 2 OR2X1 $T=188600 187680 1 0 $X=188420 $Y=183235
X12245 VSS: 2 VSS: 2682 2683 2680 2 NAND2X4_HS $T=190440 187680 0 0 $X=190260 $Y=187415
X12249 VSS: 2 VSS: 2175 635 2684 2685 2 OAI21X2_HS $T=186300 195960 1 0 $X=186120 $Y=191515
X12255 VSS: 2 VSS: 2684 635 2685 2 NAND2X2_HS $T=187220 195960 0 0 $X=187040 $Y=195695
X12259 VSS: 2 VSS: 2878 415 2880 2 NAND2X4_HS $T=196420 195960 0 0 $X=196240 $Y=195695
X12261 VSS: 2 VSS: 2685 2348 1624 2349 2687 2 AOI22X2_HS $T=185840 204240 1 0 $X=185660 $Y=199795
X12267 VSS: 2 VSS: 2690 2688 1835 2 OR2X1 $T=187220 204240 0 0 $X=187040 $Y=203975
X12271 VSS: 2 VSS: 2688 addr_i[5] 2 INVX1 $T=195960 204240 0 0 $X=195780 $Y=203975
X12272 VSS: 2 VSS: 2428 2443 2689 2 NAND2X1_HS $T=183080 212520 0 180 $X=180600 $Y=208075
X12276 VSS: 2 VSS: 2691 2690 2196 2 NAND2X4_HS $T=192280 212520 1 0 $X=192100 $Y=208075
X12277 VSS: 2 VSS: 2443 577 2 BUFX2_HS $T=184000 212520 1 180 $X=181060 $Y=212255
X12281 VSS: 2 VSS: 2693 2189 2692 2 NAND2X4_HS $T=187220 212520 0 0 $X=187040 $Y=212255
X12286 VSS: 2 VSS: 2692 415 2694 2 NAND2X4_HS $T=191360 220800 0 180 $X=186120 $Y=216355
X12288 VSS: 2 VSS: 284 2888 2 BUFX8 $T=197340 220800 0 180 $X=192100 $Y=216355
X12293 VSS: 2 VSS: 292 2890 2 BUFX8 $T=201480 220800 1 180 $X=196240 $Y=220535
X12297 VSS: 2 VSS: 2700 635 2 INVX2 $T=189060 229080 0 180 $X=187500 $Y=224635
X12301 VSS: 2 VSS: 2198 118 2697 2 OR2X2 $T=196420 229080 0 180 $X=193940 $Y=224635
X12305 VSS: 2 VSS: 2701 635 2 CLKINVX2 $T=188140 229080 0 0 $X=187960 $Y=228815
X12309 VSS: 2 VSS: 2894 1525 addr_i[3] 2 NAND2X1 $T=195500 229080 0 0 $X=195320 $Y=228815
X12311 VSS: 2 VSS: 2698 2703 2 INVX2_HS $T=184000 237360 0 180 $X=181520 $Y=232915
X12312 VSS: 2 VSS: 2703 2349 1624 2348 2302 2 AOI22X2_HS $T=184000 237360 1 0 $X=183820 $Y=232915
X12318 VSS: 2 VSS: 2704 addr_i[3] 415 1949 2705 2 AOI22X2_HS $T=195040 237360 1 180 $X=189340 $Y=237095
X12323 VSS: 2 VSS: 2210 2702 1641 2 AND2X1 $T=189980 245640 1 0 $X=189800 $Y=241195
X12326 VSS: 2 VSS: 2895 2707 2 CLKINVX2_HS $T=195040 245640 1 0 $X=194860 $Y=241195
X12328 VSS: 2 VSS: 2354 2708 2 BUFX4 $T=185380 245640 1 180 $X=182440 $Y=245375
X12331 VSS: 2 VSS: 2707 addr_i[2] 415 1525 657 2 AOI22X2_HS $T=196420 245640 1 180 $X=190720 $Y=245375
X12338 VSS: 2 VSS: 2710 addr_i[2] 415 1949 2709 2 AOI22X2_HS $T=197800 253920 0 180 $X=192100 $Y=249475
X12340 VSS: 2 VSS: 2467 2711 2 INVX2 $T=183540 253920 1 180 $X=181980 $Y=253655
X12343 VSS: 2 VSS: 2711 2695 1641 2 AND2X1 $T=189980 253920 1 180 $X=187500 $Y=253655
X12346 VSS: 2 VSS: 2898 2710 2 INVX8_HS $T=194120 253920 0 0 $X=193940 $Y=253655
X12350 VSS: 2 VSS: 2715 2712 2642 2713 2 NAND3X2_HS $T=191820 262200 1 0 $X=191640 $Y=257755
X12355 VSS: 2 VSS: 2705 1298 2 BUFX4_HS $T=184460 262200 0 0 $X=184280 $Y=261935
X12358 VSS: 2 VSS: 2713 384 302 2 XNOR2X1_HS $T=196420 262200 1 180 $X=192100 $Y=261935
X12361 VSS: 2 VSS: 2475 635 2 CLKINVX2 $T=183080 270480 0 180 $X=181520 $Y=266035
X12364 VSS: 2 VSS: 116 1298 2 CLKBUFX2 $T=185840 270480 1 0 $X=185660 $Y=266035
X12367 VSS: 2 VSS: 2716 2618 2078 2 XOR2X1_HS $T=190440 270480 1 0 $X=190260 $Y=266035
X12373 VSS: 2 VSS: 2718 2719 2717 2 NOR2X2_HS $T=193660 270480 0 0 $X=193480 $Y=270215
X12376 VSS: 2 VSS: 2683 415 1066 2 NAND2X4_HS $T=184000 278760 1 0 $X=183820 $Y=274315
X12384 VSS: 2 VSS: 2721 2722 2 CLKINVX1_HS $T=190900 278760 1 180 $X=187960 $Y=278495
X12387 VSS: 2 VSS: 2722 2720 2718 2 NAND2X1_HS $T=195960 278760 1 180 $X=193480 $Y=278495
X12391 VSS: 2 VSS: 2719 2504 404 2 XOR2X1_HS $T=183080 287040 1 0 $X=182900 $Y=282595
X12395 VSS: 2 VSS: 2724 2723 2715 2 NOR2X2_HS $T=192280 287040 1 0 $X=192100 $Y=282595
X12397 VSS: 2 VSS: 2725 2686 617 118 2 MX2X1_HS $T=188140 287040 1 180 $X=183820 $Y=286775
X12398 VSS: 2 VSS: 2727 1775 2629 2 XOR2X1_HS $T=188140 287040 0 0 $X=187960 $Y=286775
X12401 VSS: 2 VSS: 2728 2726 2727 2 NOR2X2_HS $T=196880 287040 1 180 $X=193480 $Y=286775
X12407 VSS: 2 VSS: 2726 2708 1780 2 XOR2X1_HS $T=198720 295320 0 180 $X=194400 $Y=290875
X12408 VSS: 2 VSS: 2227 2488 2729 2 NAND2X1 $T=181700 295320 0 0 $X=181520 $Y=295055
X12410 VSS: 2 VSS: 2732 2731 2 INVX2 $T=188600 295320 1 180 $X=187040 $Y=295055
X12414 VSS: 2 VSS: 1587 2730 1641 2 AND2X1 $T=194120 295320 1 180 $X=191640 $Y=295055
X12419 VSS: 2 VSS: 120 2732 2733 2438 2 OAI21X2_HS $T=185840 303600 1 0 $X=185660 $Y=299155
X12423 VSS: 2 VSS: 2733 2916 2438 2 NAND2X4_HS $T=200560 303600 0 180 $X=195320 $Y=299155
X12424 VSS: 2 VSS: 2486 794 2735 2 NOR2X2_HS $T=180780 303600 0 0 $X=180600 $Y=303335
X12428 VSS: 2 VSS: 2736 2724 2734 2 NAND2X2_HS $T=195040 303600 1 180 $X=191640 $Y=303335
X12431 VSS: 2 VSS: 2488 794 2735 2 NAND2X1 $T=186760 311880 1 0 $X=186580 $Y=307435
X12435 VSS: 2 VSS: 2490 2737 2 CLKBUFX2 $T=185840 311880 1 180 $X=183360 $Y=311615
X12442 VSS: 2 VSS: 2497 2731 2 INVX4_HS $T=190900 320160 0 180 $X=187500 $Y=315715
X12448 VSS: 2 VSS: 121 2665 2864 2 XOR2X1_HS $T=198720 320160 1 180 $X=194400 $Y=319895
X12451 VSS: 2 VSS: 122 2739 2500 2 NAND2X2_HS $T=189060 328440 0 180 $X=185660 $Y=323995
X12459 VSS: 2 VSS: 2738 635 2269 2 NOR2X1_HS $T=192740 328440 0 0 $X=192560 $Y=328175
X12462 VSS: 2 VSS: 2506 119 2740 2741 2721 2 NAND4X4_HS $T=181700 336720 1 0 $X=181520 $Y=332275
X12465 VSS: 2 VSS: 2930 2687 2888 2 XOR2X1_HS $T=195960 336720 1 0 $X=195780 $Y=332275
X12468 VSS: 2 VSS: 2741 2743 2 CLKINVX1_HS $T=189060 336720 1 180 $X=186120 $Y=336455
X12470 VSS: 2 VSS: 2743 1354 2742 2 NAND2X1_HS $T=190900 336720 0 0 $X=190720 $Y=336455
X12474 VSS: 2 VSS: 2740 2744 2 CLKINVX1_HS $T=183080 345000 1 0 $X=182900 $Y=340555
X12477 VSS: 2 VSS: 2745 813 113 2 AND2X1_HS $T=188140 345000 1 0 $X=187960 $Y=340555
X12482 VSS: 2 VSS: 2746 2745 2 BUFX16_HS $T=195040 345000 1 180 $X=184740 $Y=344735
X12484 VSS: 2 VSS: 2513 840 1090 2 XOR2X1_HS $T=185380 353280 0 180 $X=181060 $Y=348835
X12487 VSS: 2 VSS: 638 2747 2 INVX4_HS $T=190900 353280 0 180 $X=187500 $Y=348835
X12494 VSS: 2 VSS: 2516 2749 2750 2 NAND2X2_HS $T=192280 353280 1 180 $X=188880 $Y=353015
X12499 VSS: 2 VSS: 2750 2269 2751 2748 2 OAI21X2_HS $T=193660 361560 0 180 $X=188880 $Y=357115
X12501 VSS: 2 VSS: 2515 2753 2754 2 NAND2X2_HS $T=180780 361560 0 0 $X=180600 $Y=361295
X12506 VSS: 2 VSS: 2749 635 2 INVX4 $T=195040 361560 1 180 $X=192560 $Y=361295
X12512 VSS: 2 VSS: 415 2755 2 CLKBUFX2 $T=188600 369840 1 0 $X=188420 $Y=365395
X12516 VSS: 2 VSS: 2751 2517 2 CLKINVX2 $T=194120 369840 1 0 $X=193940 $Y=365395
X12521 VSS: 2 VSS: 2557 2757 1949 410 2730 2 AOI22X1 $T=191360 369840 1 180 $X=188420 $Y=369575
X12524 VSS: 2 VSS: 2517 639 2759 2 NOR2X2 $T=180780 378120 1 0 $X=180600 $Y=373675
X12528 VSS: 2 VSS: 2752 2522 2758 2 NAND2X2_HS $T=186760 378120 1 0 $X=186580 $Y=373675
X12532 VSS: 2 VSS: 2791 2946 1949 410 2706 2 AOI22X1 $T=195960 378120 1 0 $X=195780 $Y=373675
X12534 VSS: 2 VSS: 2759 673 2 INVX1 $T=181700 378120 0 0 $X=181520 $Y=377855
X12538 VSS: 2 VSS: 2758 2760 2 INVX2 $T=188140 378120 0 0 $X=187960 $Y=377855
X12541 VSS: 2 VSS: 2519 2761 2 INVX8_HS $T=196880 378120 1 180 $X=191640 $Y=377855
X12544 VSS: 2 VSS: 2760 674 2 INVX1 $T=184000 386400 1 0 $X=183820 $Y=381955
X12552 VSS: 2 VSS: 2524 2755 2 CLKINVX1 $T=189520 386400 1 180 $X=187960 $Y=386135
X12555 VSS: 2 VSS: 2764 1641 2757 2 NAND2X4_HS $T=196880 386400 1 180 $X=191640 $Y=386135
X12561 VSS: 2 VSS: 2766 2755 2765 2 AND2X1_HS $T=195500 394680 0 180 $X=192560 $Y=390235
X12564 VSS: 2 VSS: 111 1364 2766 2 AND2X1_HS $T=188600 394680 1 180 $X=185660 $Y=394415
X12568 VSS: 2 VSS: 2768 2767 2755 2 AND2X1_HS $T=196420 394680 1 180 $X=193480 $Y=394415
X12572 VSS: 2 VSS: 2526 1364 2768 2 AND2X1_HS $T=189060 402960 0 180 $X=186120 $Y=398515
X12576 VSS: 2 VSS: 2769 2764 2 INVX4_HS $T=192280 402960 1 0 $X=192100 $Y=398515
X12578 VSS: 2 VSS: 2527 1364 2771 2 AND2X1_HS $T=184920 402960 1 180 $X=181980 $Y=402695
X12581 VSS: 2 VSS: 2771 2755 2770 2 AND2X1_HS $T=191820 402960 1 180 $X=188880 $Y=402695
X12584 VSS: 2 VSS: 2962 2755 2946 2 NAND2X4_HS $T=201020 402960 1 180 $X=195780 $Y=402695
X12588 VSS: 2 VSS: 2773 1364 2 CLKINVX2 $T=191820 411240 0 180 $X=190260 $Y=406795
X12594 VSS: 2 VSS: 2534 2773 2772 2 NOR2X4_HS $T=186300 411240 0 0 $X=186120 $Y=410975
X12597 VSS: 2 VSS: 2774 2962 2 INVX2_HS $T=198260 411240 1 180 $X=195780 $Y=410975
X12601 VSS: 2 VSS: 1670 1364 2774 2 AND2X2_HS $T=195040 419520 0 180 $X=191640 $Y=415075
X12605 VSS: 2 VSS: 2536 2776 2775 2 NAND2X4_HS $T=193660 419520 1 180 $X=188420 $Y=419255
X12608 VSS: 2 VSS: 1385 2776 2775 2 NAND2X4_HS $T=188140 427800 0 180 $X=182900 $Y=423355
X12615 VSS: 2 VSS: 2538 2595 2 CLKBUFX2 $T=193660 427800 1 180 $X=191180 $Y=427535
X12628 VSS: 2 VSS: 1394 2777 2 BUFX8_HS $T=192740 444360 0 180 $X=187040 $Y=439915
X12643 VSS: 2 VSS: 1980 7556 2018 2547 2 DFFX1_HS $T=185380 452640 0 0 $X=185200 $Y=452375
X12646 VSS: 2 VSS: 2779 1168 2549 2568 2 AOI21X1 $T=182620 460920 1 0 $X=182440 $Y=456475
X12649 VSS: 2 VSS: 2780 2778 2 CLKBUFX8 $T=195500 460920 0 180 $X=190260 $Y=456475
X12654 VSS: 2 VSS: 1685 7557 2018 2780 2 DFFX1_HS $T=188140 460920 0 0 $X=187960 $Y=460655
X12660 VSS: 2 VSS: 2551 2781 2317 2319 1155 2 AOI22X1 $T=180780 469200 0 0 $X=180600 $Y=468935
X12667 VSS: 2 VSS: 1693 7558 1893 2780 2 DFFX1_HS $T=189060 477480 1 0 $X=188880 $Y=473035
X12671 VSS: 2 VSS: 2784 1424 2783 2568 2 AOI21X1 $T=190440 477480 1 180 $X=187960 $Y=477215
X12679 VSS: 2 VSS: 2986 2794 2785 2796 917 2 AOI22X1 $T=195960 485760 1 0 $X=195780 $Y=481315
X12684 VSS: 2 VSS: 2788 2787 2000 2786 2784 2 NAND4X1_HS $T=194120 485760 1 180 $X=190720 $Y=485495
X12690 VSS: 2 VSS: 2789 2566 2790 2 NAND2X1 $T=192280 494040 1 0 $X=192100 $Y=489595
X12699 VSS: 2 VSS: 2793 1717 2789 2568 2 AOI21X1 $T=189520 502320 1 0 $X=189340 $Y=497875
X12710 VSS: 2 VSS: 934 2996 2 BUFX16_HS $T=206080 510600 0 180 $X=195780 $Y=506155
X12712 VSS: 2 VSS: 920 7559 2018 2571 2 DFFX1_HS $T=191360 510600 0 0 $X=191180 $Y=510335
X12713 VSS: 2 VSS: 1424 7560 1893 2570 2 DFFX1_HS $T=184920 518880 1 0 $X=184740 $Y=514435
X12714 VSS: 2 VSS: 936 7561 1914 2571 2 DFFX1_HS $T=194120 518880 1 0 $X=193940 $Y=514435
X12715 VSS: 2 VSS: 1172 7562 2015 2571 2 DFFX1_HS $T=184920 518880 0 0 $X=184740 $Y=518615
X12719 VSS: 2 VSS: 1717 7563 2015 2570 2 DFFX1_HS $T=188140 527160 1 0 $X=187960 $Y=522715
X12723 VSS: 2 VSS: 2797 2795 2785 2796 1438 2 AOI22X1 $T=192280 527160 0 0 $X=192100 $Y=526895
X12732 VSS: 2 VSS: 1983 7564 1893 2799 2 DFFX1_HS $T=187220 535440 0 0 $X=187040 $Y=535175
X12733 VSS: 2 VSS: 1981 7565 2018 2799 2 DFFX1_HS $T=196420 535440 0 0 $X=196240 $Y=535175
X12735 VSS: 2 VSS: 1976 7566 2018 2800 2 DFFX1_HS $T=192280 543720 1 0 $X=192100 $Y=539275
X12737 VSS: 2 VSS: 1677 7567 1893 2800 2 DFFX1_HS $T=191820 543720 0 0 $X=191640 $Y=543455
X12740 VSS: 2 VSS: 2573 2801 2785 2796 706 2 AOI22X1 $T=186300 552000 1 0 $X=186120 $Y=547555
X12746 VSS: 2 VSS: 1163 7568 1893 2802 2 DFFX1_HS $T=186760 552000 0 0 $X=186580 $Y=551735
X12749 VSS: 2 VSS: 1155 7569 2018 2802 2 DFFX1_HS $T=181700 560280 1 0 $X=181520 $Y=555835
X12753 VSS: 2 VSS: 1187 7570 1561 2802 2 DFFX1_HS $T=181700 560280 0 0 $X=181520 $Y=560015
X12760 VSS: 2 VSS: 2024 7571 2015 2800 2 DFFX1_HS $T=189060 568560 1 0 $X=188880 $Y=564115
X12763 VSS: 2 VSS: 1729 7572 2015 2780 2 DFFX1_HS $T=189980 568560 0 0 $X=189800 $Y=568295
X12767 VSS: 2 VSS: 1733 7573 1914 2780 2 DFFX1_HS $T=191360 576840 1 0 $X=191180 $Y=572395
X12768 VSS: 2 VSS: 1192 7574 1914 2802 2 DFFX1_HS $T=181700 576840 0 0 $X=181520 $Y=576575
X12771 VSS: 2 VSS: 1732 7575 1561 2780 2 DFFX1_HS $T=193200 576840 0 0 $X=193020 $Y=576575
X12774 VSS: 2 VSS: 2584 2803 2555 2564 1458 2 AOI22X1 $T=186300 585120 1 0 $X=186120 $Y=580675
X12780 VSS: 2 VSS: 2035 7576 2015 2799 2 DFFX1_HS $T=191820 585120 0 0 $X=191640 $Y=584855
X12790 VSS: 2 VSS: 2587 2804 2317 2319 1187 2 AOI22X1 $T=191360 593400 0 0 $X=191180 $Y=593135
X12795 VSS: 2 VSS: 2031 7577 2015 2547 2 DFFX1_HS $T=180780 601680 0 0 $X=180600 $Y=601415
X12800 VSS: 2 VSS: 2588 2805 2555 2564 1466 2 AOI22X1 $T=186760 609960 1 0 $X=186580 $Y=605515
X12806 VSS: 2 VSS: 2045 7578 1914 2806 2 DFFX1_HS $T=192740 609960 0 0 $X=192560 $Y=609695
X12810 VSS: 2 VSS: 2593 2807 2555 2564 1205 2 AOI22X1 $T=186760 618240 1 0 $X=186580 $Y=613795
X12814 VSS: 2 VSS: 1205 7579 1914 2578 2 DFFX1_HS $T=183080 618240 0 0 $X=182900 $Y=617975
X12817 VSS: 2 VSS: 1207 7580 1561 2800 2 DFFX1_HS $T=195040 618240 0 0 $X=194860 $Y=617975
X12825 VSS: 2 VSS: 2047 7581 1561 2799 2 DFFX1_HS $T=187680 626520 0 0 $X=187500 $Y=626255
X12830 VSS: 2 VSS: 2048 7582 1914 2799 2 DFFX1_HS $T=190440 634800 1 0 $X=190260 $Y=630355
X12842 VSS: 2 VSS: 2808 2810 2 CLKBUFX4 $T=207920 13800 1 0 $X=207740 $Y=9355
X12850 VSS: 2 VSS: 2810 2345 2811 2 NOR2X1 $T=201940 13800 0 0 $X=201760 $Y=13535
X12854 VSS: 2 VSS: 2809 2345 2812 2 NOR2X1 $T=209760 13800 0 0 $X=209580 $Y=13535
X12859 VSS: 2 VSS: 2813 2814 2811 2 NOR2X1 $T=205620 22080 1 0 $X=205440 $Y=17635
X12866 VSS: 2 VSS: 2811 2621 addr_i[2] 2608 2 NAND3X1 $T=201480 22080 1 180 $X=199000 $Y=21815
X12869 VSS: 2 VSS: 2815 2811 1634 2 OR2X1 $T=203780 22080 0 0 $X=203600 $Y=21815
X12873 VSS: 2 VSS: 2816 2812 1634 2 OR2X1 $T=211140 22080 0 0 $X=210960 $Y=21815
X12877 VSS: 2 VSS: 2812 2621 addr_i[3] addr_i[2] 2 NAND3X1 $T=201020 30360 1 0 $X=200840 $Y=25915
X12879 VSS: 2 VSS: 2817 addr_i[4] 2608 2818 2 NAND3X1 $T=207000 30360 1 0 $X=206820 $Y=25915
X12881 VSS: 2 VSS: 3026 2814 2812 2 NOR2X1 $T=212980 30360 1 0 $X=212800 $Y=25915
X12885 VSS: 2 VSS: 2819 addr_i[4] 2608 addr_i[2] 2 NAND3X1 $T=196880 30360 0 0 $X=196700 $Y=30095
X12888 VSS: 2 VSS: 2818 addr_i[2] 2 INVX1 $T=201940 30360 0 0 $X=201760 $Y=30095
X12889 VSS: 2 VSS: 2820 2818 addr_i[3] addr_i[4] 2 NAND3X1 $T=205620 30360 1 180 $X=203140 $Y=30095
X12892 VSS: 2 VSS: 3027 2814 2819 2 NOR2X1 $T=212980 30360 0 0 $X=212800 $Y=30095
X12895 VSS: 2 VSS: 2814 2613 2615 2 NAND2X1 $T=199640 38640 1 0 $X=199460 $Y=34195
X12898 VSS: 2 VSS: 2821 2814 2820 2 NOR2X1 $T=205620 38640 1 0 $X=205440 $Y=34195
X12905 VSS: 2 VSS: 2823 2614 2822 2 NOR2X1 $T=200100 38640 0 0 $X=199920 $Y=38375
X12908 VSS: 2 VSS: 2824 2820 1634 2 OR2X1 $T=209300 38640 0 0 $X=209120 $Y=38375
X12912 VSS: 2 VSS: 2825 2616 2 CLKBUFX2 $T=203320 46920 1 0 $X=203140 $Y=42475
X12915 VSS: 2 VSS: 3032 2816 2822 2 NOR2X1 $T=212980 46920 1 0 $X=212800 $Y=42475
X12922 VSS: 2 VSS: 2345 2613 2619 addr_i[5] 2 NAND3X1 $T=199640 46920 0 0 $X=199460 $Y=46655
X12925 VSS: 2 VSS: 2827 2345 2820 2 NOR2X1 $T=206080 46920 0 0 $X=205900 $Y=46655
X12928 VSS: 2 VSS: 2826 2819 1634 2 OR2X1 $T=212980 46920 1 180 $X=210500 $Y=46655
X12932 VSS: 2 VSS: 2828 addr_i[5] 2619 2 OR2X1 $T=200560 55200 1 0 $X=200380 $Y=50755
X12937 VSS: 2 VSS: 3036 2826 2828 2 NOR2X1 $T=212520 55200 1 0 $X=212340 $Y=50755
X12941 VSS: 2 VSS: 2822 addr_i[6] addr_i[5] 2 NAND2X1 $T=196880 55200 0 0 $X=196700 $Y=54935
X12944 VSS: 2 VSS: 2829 2824 2828 2 NOR2X1 $T=207920 55200 1 180 $X=205900 $Y=54935
X12949 VSS: 2 VSS: 2830 2614 2828 2 NOR2X1 $T=202400 63480 0 180 $X=200380 $Y=59035
X12954 VSS: 2 VSS: 3041 2826 2822 2 NOR2X1 $T=212060 63480 1 0 $X=211880 $Y=59035
X12961 VSS: 2 VSS: 2831 2824 2822 2 NOR2X1 $T=206080 63480 0 0 $X=205900 $Y=63215
X12966 VSS: 2 VSS: 2833 2613 2623 2 NAND2X1 $T=199640 71760 1 0 $X=199460 $Y=67315
X12970 VSS: 2 VSS: 2832 2622 2822 2 NOR2X1 $T=210680 71760 1 0 $X=210500 $Y=67315
X12978 VSS: 2 VSS: 2834 2828 2815 2 NOR2X1 $T=204700 71760 1 180 $X=202680 $Y=71495
X12981 VSS: 2 VSS: 2835 2622 2828 2 NOR2X1 $T=207460 71760 0 0 $X=207280 $Y=71495
X12992 VSS: 2 VSS: 2568 2834 2 BUFX4_HS $T=204700 80040 1 180 $X=200840 $Y=79775
X12995 VSS: 2 VSS: 2836 2822 2815 2 NOR2X1 $T=208840 80040 0 0 $X=208660 $Y=79775
X13000 VSS: 2 VSS: 2837 2831 2 CLKBUFX2 $T=206080 88320 1 0 $X=205900 $Y=83875
X13012 VSS: 2 VSS: 3046 2836 2 CLKBUFX2 $T=212980 88320 0 0 $X=212800 $Y=88055
X13018 VSS: 2 VSS: 2311 2835 2 CLKBUFX4 $T=209300 96600 1 0 $X=209120 $Y=92155
X13026 VSS: 2 VSS: 2840 635 2 INVX4 $T=204700 96600 0 0 $X=204520 $Y=96335
X13027 VSS: 2 VSS: 2841 2840 2 INVX2 $T=207000 96600 0 0 $X=206820 $Y=96335
X13032 VSS: 2 VSS: 2843 2841 2838 2 NAND2X2_HS $T=207920 104880 0 180 $X=204520 $Y=100435
X13035 VSS: 2 VSS: 2633 118 2842 2 OR2X2 $T=212980 104880 0 180 $X=210500 $Y=100435
X13041 VSS: 2 VSS: 2844 2838 2 INVX2_HS $T=200100 104880 0 0 $X=199920 $Y=104615
X13046 VSS: 2 VSS: 2848 2847 2844 2 NAND2X2_HS $T=204700 113160 0 180 $X=201300 $Y=108715
X13048 VSS: 2 VSS: 2847 635 2 CLKINVX2 $T=205160 113160 1 0 $X=204980 $Y=108715
X13050 VSS: 2 VSS: 2628 118 2845 2 OR2X1 $T=210680 113160 0 180 $X=208200 $Y=108715
X13055 VSS: 2 VSS: 2650 2848 2843 2 NAND2X4_HS $T=203320 113160 1 180 $X=198080 $Y=112895
X13059 VSS: 2 VSS: 2845 2849 2 INVX2 $T=210680 113160 1 180 $X=209120 $Y=112895
X13064 VSS: 2 VSS: 2651 118 2850 2 OR2X2 $T=206080 121440 0 180 $X=203600 $Y=116995
X13066 VSS: 2 VSS: 2850 2851 2 INVX2 $T=211140 121440 0 180 $X=209580 $Y=116995
X13074 VSS: 2 VSS: 2389 118 2852 2 OR2X1 $T=209760 121440 1 180 $X=207280 $Y=121175
X13077 VSS: 2 VSS: 2717 2839 1229 2 XOR2X1_HS $T=205160 129720 0 180 $X=200840 $Y=125275
X13086 VSS: 2 VSS: 2855 2612 2069 2 NOR2X4_HS $T=201940 129720 0 0 $X=201760 $Y=129455
X13089 VSS: 2 VSS: 2647 118 2854 2 OR2X2 $T=212060 129720 1 180 $X=209580 $Y=129455
X13094 VSS: 2 VSS: 2857 2853 2632 520 2 AOI21X2_HS $T=204700 138000 0 180 $X=199920 $Y=133555
X13097 VSS: 2 VSS: 2656 118 2856 2 OR2X2 $T=211600 138000 0 180 $X=209120 $Y=133555
X13103 VSS: 2 VSS: 2859 2855 2612 2069 2 AOI21X2_HS $T=202860 138000 0 0 $X=202680 $Y=137735
X13106 VSS: 2 VSS: 2641 118 2858 2 OR2X2 $T=212520 138000 1 180 $X=210040 $Y=137735
X13109 VSS: 2 VSS: 2663 2862 2662 2 NAND2X2_HS $T=202400 146280 0 180 $X=199000 $Y=141835
X13111 VSS: 2 VSS: 2862 635 2 INVX2_HS $T=205160 146280 0 180 $X=202680 $Y=141835
X13114 VSS: 2 VSS: 1810 118 2861 2 OR2X2 $T=210220 146280 0 180 $X=207740 $Y=141835
X13119 VSS: 2 VSS: 2662 2863 2 INVX2_HS $T=197340 146280 0 0 $X=197160 $Y=146015
X13127 VSS: 2 VSS: 2865 2624 2102 2 XOR2X1_HS $T=209760 154560 0 180 $X=205440 $Y=150115
X13131 VSS: 2 VSS: 2858 3063 2 INVX2 $T=214360 154560 0 180 $X=212800 $Y=150115
X13137 VSS: 2 VSS: 2668 2349 1624 2348 2866 2 AOI22X2_HS $T=199640 154560 0 0 $X=199460 $Y=154295
X13143 VSS: 2 VSS: 134 2868 2 BUFX16_HS $T=201480 162840 1 0 $X=201300 $Y=158395
X13150 VSS: 2 VSS: 2868 1822 2869 2 AND2X1_HS $T=204240 162840 1 180 $X=201300 $Y=162575
X13151 VSS: 2 VSS: 2869 2867 1301 118 2 MX2X1 $T=207920 162840 1 180 $X=204060 $Y=162575
X13155 VSS: 2 VSS: 3068 964 2 BUFX2 $T=212980 162840 0 0 $X=212800 $Y=162575
X13162 VSS: 2 VSS: 3067 wdata_i[23] 1641 1949 3068 2 AOI22X2_HS $T=210680 171120 1 0 $X=210500 $Y=166675
X13169 VSS: 2 VSS: 2873 1822 2872 2 AND2X1_HS $T=205160 171120 1 180 $X=202220 $Y=170855
X13174 VSS: 2 VSS: 2871 2873 2 BUFX16_HS $T=209300 179400 0 180 $X=199000 $Y=174955
X13177 VSS: 2 VSS: 2875 2874 2 INVX2 $T=212980 179400 0 180 $X=211420 $Y=174955
X13183 VSS: 2 VSS: 2872 2875 2877 118 2 OAI21X1_HS $T=204700 179400 1 180 $X=201760 $Y=179135
X13189 VSS: 2 VSS: 2877 118 1276 2 NAND2X2 $T=201020 187680 1 0 $X=200840 $Y=183235
X13198 VSS: 2 VSS: 2876 2878 2679 2 NAND2X4_HS $T=198260 187680 0 0 $X=198080 $Y=187415
X13202 VSS: 2 VSS: 3077 wdata_i[13] 1641 1949 3079 2 AOI22X1 $T=215280 187680 1 180 $X=212340 $Y=187415
X13206 VSS: 2 VSS: 2686 2879 1641 2 AND2X1 $T=208840 195960 0 180 $X=206360 $Y=191515
X13209 VSS: 2 VSS: 3079 2495 2 CLKBUFX2 $T=212980 195960 1 0 $X=212800 $Y=191515
X13214 VSS: 2 VSS: 2880 1301 2 CLKBUFX2_HS $T=206540 195960 1 180 $X=203140 $Y=195695
X13219 VSS: 2 VSS: 2881 2620 2355 2 NOR2X4_HS $T=208380 204240 0 180 $X=203140 $Y=199795
X13229 VSS: 2 VSS: 2882 2691 2 BUFX8_HS $T=204240 204240 0 0 $X=204060 $Y=203975
X13235 VSS: 2 VSS: 2883 302 2 CLKBUFX2 $T=202400 212520 1 0 $X=202220 $Y=208075
X13238 VSS: 2 VSS: 2884 2881 2 INVX2_HS $T=210220 212520 1 0 $X=210040 $Y=208075
X13243 VSS: 2 VSS: 2886 2675 2427 2 XOR2X1_HS $T=196880 212520 0 0 $X=196700 $Y=212255
X13247 VSS: 2 VSS: 1863 2885 1641 2 AND2X1 $T=210220 212520 0 0 $X=210040 $Y=212255
X13252 VSS: 2 VSS: 2448 2887 1641 2 AND2X1 $T=204700 220800 0 180 $X=202220 $Y=216355
X13262 VSS: 2 VSS: 1887 2889 1641 2 AND2X1 $T=210220 220800 1 180 $X=207740 $Y=220535
X13266 VSS: 2 VSS: 2697 2892 2 CLKINVX1 $T=202860 229080 0 180 $X=201300 $Y=224635
X13270 VSS: 2 VSS: 2892 2891 1641 2 AND2X1 $T=208380 229080 0 180 $X=205900 $Y=224635
X13278 VSS: 2 VSS: 2893 2894 2479 2 NAND2X4_HS $T=201940 229080 0 0 $X=201760 $Y=228815
X13281 VSS: 2 VSS: 3093 2893 2 BUFX16_HS $T=211140 229080 0 0 $X=210960 $Y=228815
X13288 VSS: 2 VSS: 2790 3095 1949 1525 2702 2 AOI22X1 $T=212980 237360 1 0 $X=212800 $Y=232915
X13296 VSS: 2 VSS: 3098 2704 2 INVX8_HS $T=211600 237360 0 0 $X=211420 $Y=237095
X13300 VSS: 2 VSS: 3100 2895 2 BUFX16_HS $T=205160 245640 1 0 $X=204980 $Y=241195
X13307 VSS: 2 VSS: 2896 2302 2 CLKBUFX2 $T=205160 245640 0 0 $X=204980 $Y=245375
X13310 VSS: 2 VSS: 2465 3102 1641 2 AND2X1 $T=212980 245640 0 0 $X=212800 $Y=245375
X13323 VSS: 2 VSS: 2217 2897 1641 2 AND2X1 $T=212520 253920 1 180 $X=210040 $Y=253655
X13326 VSS: 2 VSS: 2712 2900 2857 2 NOR2X4_HS $T=200560 262200 1 0 $X=200380 $Y=257755
X13328 VSS: 2 VSS: 2469 118 2899 2 OR2X1 $T=211600 262200 0 180 $X=209120 $Y=257755
X13335 VSS: 2 VSS: 2900 577 2901 2902 2 OAI21X2_HS $T=201480 262200 0 0 $X=201300 $Y=261935
X13338 VSS: 2 VSS: 2903 2716 2886 2 NOR2X1_HS $T=200560 270480 0 180 $X=198080 $Y=266035
X13341 VSS: 2 VSS: 2902 2302 2 CLKINVX2 $T=207460 270480 0 180 $X=205900 $Y=266035
X13343 VSS: 2 VSS: 2904 3111 2 BUFX8_HS $T=216660 270480 0 180 $X=210960 $Y=266035
X13348 VSS: 2 VSS: 2901 2905 577 2 NAND2X4_HS $T=205620 270480 1 180 $X=200380 $Y=270215
X13350 VSS: 2 VSS: 2905 2302 2 INVX4 $T=207460 270480 0 0 $X=207280 $Y=270215
X13353 VSS: 2 VSS: 2720 2907 2859 2 NOR2X2_HS $T=198720 278760 1 0 $X=198540 $Y=274315
X13357 VSS: 2 VSS: 2906 2908 2 CLKINVX4 $T=210220 278760 1 0 $X=210040 $Y=274315
X13365 VSS: 2 VSS: 2908 wdata_i[12] 1641 1949 2909 2 AOI22X2_HS $T=210220 278760 1 180 $X=204520 $Y=278495
X13368 VSS: 2 VSS: 2723 2903 2728 2 NAND2X1_HS $T=200560 287040 0 180 $X=198080 $Y=282595
X13372 VSS: 2 VSS: 2909 2911 2 CLKBUFX2 $T=205620 287040 1 0 $X=205440 $Y=282595
X13376 VSS: 2 VSS: 3118 2866 2890 2 XOR2X1_HS $T=211140 287040 1 0 $X=210960 $Y=282595
X13382 VSS: 2 VSS: 2913 2725 2 BUFX8_HS $T=200560 287040 0 0 $X=200380 $Y=286775
X13385 VSS: 2 VSS: 170 2912 2 BUFX8 $T=213440 287040 1 180 $X=208200 $Y=286775
X13390 VSS: 2 VSS: 3124 2914 2904 2 NAND2X4_HS $T=210220 295320 1 0 $X=210040 $Y=290875
X13396 VSS: 2 VSS: 2907 2915 2495 1828 2 AOI21X2_HS $T=205160 295320 1 180 $X=200380 $Y=295055
X13399 VSS: 2 VSS: 3126 3125 3124 1303 2 OAI21X2_HS $T=217120 295320 1 180 $X=212340 $Y=295055
X13402 VSS: 2 VSS: 2915 2495 1828 2 NOR2X4_HS $T=203320 303600 1 0 $X=203140 $Y=299155
X13405 VSS: 2 VSS: 2916 2731 2 CLKINVX2 $T=212520 303600 0 180 $X=210960 $Y=299155
X13412 VSS: 2 VSS: 2918 2917 2 INVX2_HS $T=205160 303600 1 180 $X=202680 $Y=303335
X13416 VSS: 2 VSS: 3128 3126 3127 2 NOR2X2_HS $T=212980 303600 0 0 $X=212800 $Y=303335
X13418 VSS: 2 VSS: 2920 2738 2918 2 NAND2X2_HS $T=198260 311880 1 0 $X=198080 $Y=307435
X13422 VSS: 2 VSS: 2917 2919 2 CLKINVX2_HS $T=207920 311880 1 0 $X=207740 $Y=307435
X13425 VSS: 2 VSS: 3131 2919 794 2 XOR2X1_HS $T=212980 311880 1 0 $X=212800 $Y=307435
X13430 VSS: 2 VSS: 2735 2921 2923 2922 2920 2 NAND4X2_HS $T=197340 311880 0 0 $X=197160 $Y=311615
X13436 VSS: 2 VSS: 2923 2752 2917 2924 2 NAND3X1_HS $T=199640 320160 1 0 $X=199460 $Y=315715
X13440 VSS: 2 VSS: 2734 2925 2 CLKINVX1_HS $T=214360 320160 0 180 $X=211420 $Y=315715
X13449 VSS: 2 VSS: 2925 3136 2926 3128 3133 2 NAND4X1_HS $T=215740 320160 1 180 $X=212340 $Y=319895
X13451 VSS: 2 VSS: 2921 635 2752 2 OR2X1 $T=201020 328440 0 180 $X=198540 $Y=323995
X13456 VSS: 2 VSS: 2926 2927 2 CLKINVX1_HS $T=207920 328440 1 0 $X=207740 $Y=323995
X13466 VSS: 2 VSS: 2927 33 2928 2 NAND2X4_HS $T=207460 328440 0 0 $X=207280 $Y=328175
X13470 VSS: 2 VSS: 2742 2865 2930 2 NOR2X2_HS $T=204700 336720 0 180 $X=201300 $Y=332275
X13479 VSS: 2 VSS: 2922 2933 2924 2 NAND2X1_HS $T=201020 336720 1 180 $X=198540 $Y=336455
X13482 VSS: 2 VSS: 2929 419 2932 2931 2 OAI21X2_HS $T=206540 336720 0 0 $X=206360 $Y=336455
X13484 VSS: 2 VSS: 2924 2934 2 INVX4_HS $T=201480 345000 0 180 $X=198080 $Y=340555
X13488 VSS: 2 VSS: 2932 2935 419 2 NAND2X4 $T=211600 345000 0 180 $X=207280 $Y=340555
X13494 VSS: 2 VSS: 2934 635 2 INVX4 $T=201480 345000 1 180 $X=199000 $Y=344735
X13498 VSS: 2 VSS: 2935 1097 2 INVX2_HS $T=204700 345000 0 0 $X=204520 $Y=344735
X13501 VSS: 2 VSS: 2936 1147 3143 2 OR2X2 $T=214820 345000 1 180 $X=212340 $Y=344735
X13503 VSS: 2 VSS: 2933 2269 2752 2 AND2X1_HS $T=197800 353280 1 0 $X=197620 $Y=348835
X13507 VSS: 2 VSS: 648 2937 2936 2 NAND2X4_HS $T=212060 353280 0 180 $X=206820 $Y=348835
X13512 VSS: 2 VSS: 2748 2938 2 INVX8_HS $T=199640 353280 0 0 $X=199460 $Y=353015
X13516 VSS: 2 VSS: 2937 2939 2282 2 NAND2X1 $T=211600 353280 1 180 $X=209580 $Y=353015
X13521 VSS: 2 VSS: 2911 1357 2 CLKBUFX2 $T=205620 361560 1 0 $X=205440 $Y=357115
X13525 VSS: 2 VSS: 2514 2940 2 INVX1 $T=212520 361560 0 180 $X=210960 $Y=357115
X13531 VSS: 2 VSS: 2942 2748 2 CLKINVX2 $T=200560 361560 0 0 $X=200380 $Y=361295
X13535 VSS: 2 VSS: 847 2941 2 INVX4_HS $T=212980 361560 1 180 $X=209580 $Y=361295
X13539 VSS: 2 VSS: 2754 2943 2942 2 NAND2X2_HS $T=201940 369840 0 180 $X=198540 $Y=365395
X13542 VSS: 2 VSS: 2944 813 2459 2 NAND2X4_HS $T=207460 369840 1 0 $X=207280 $Y=365395
X13548 VSS: 2 VSS: 2943 2269 2 INVX1_HS $T=198720 369840 0 0 $X=198540 $Y=369575
X13551 VSS: 2 VSS: 2945 2944 2 INVX16_HS $T=214360 369840 1 180 $X=205900 $Y=369575
X13555 VSS: 2 VSS: 2782 2947 1949 410 2695 2 AOI22X1 $T=205160 378120 1 0 $X=204980 $Y=373675
X13564 VSS: 2 VSS: 112 1364 2948 2 CLKAND2X2 $T=208380 378120 1 180 $X=205900 $Y=377855
X13569 VSS: 2 VSS: 2950 2755 2947 2 AND2X1_HS $T=204240 386400 0 180 $X=201300 $Y=381955
X13573 VSS: 2 VSS: 90 2949 2 CLKBUFX2 $T=211600 386400 0 180 $X=209120 $Y=381955
X13576 VSS: 2 VSS: 2755 2951 2 INVX2 $T=214360 386400 0 180 $X=212800 $Y=381955
X13582 VSS: 2 VSS: 2525 2950 1364 2 AND2X2_HS $T=204240 386400 1 180 $X=200840 $Y=386135
X13585 VSS: 2 VSS: 1641 2951 2 INVX16_HS $T=208380 386400 0 0 $X=208200 $Y=386135
X13588 VSS: 2 VSS: 2951 97 2 INVX4_HS $T=200560 394680 1 0 $X=200380 $Y=390235
X13590 VSS: 2 VSS: 2953 2755 2952 2 NAND2X4_HS $T=212520 394680 0 180 $X=207280 $Y=390235
X13596 VSS: 2 VSS: 2957 2953 2 INVX2_HS $T=202860 394680 1 180 $X=200380 $Y=394415
X13599 VSS: 2 VSS: 2956 1364 2955 2 NAND2X4_HS $T=205160 394680 0 0 $X=204980 $Y=394415
X13602 VSS: 2 VSS: 2955 2954 2 CLKINVX2_HS $T=211600 394680 0 0 $X=211420 $Y=394415
X13603 VSS: 2 VSS: 110 1364 2957 2 AND2X2_HS $T=202400 402960 0 180 $X=199000 $Y=398515
X13606 VSS: 2 VSS: 2959 2755 2958 2 NAND2X4_HS $T=212980 402960 0 180 $X=207740 $Y=398515
X13614 VSS: 2 VSS: 2961 2755 2960 2 NAND2X4_HS $T=206080 402960 0 0 $X=205900 $Y=402695
X13620 VSS: 2 VSS: 2772 2755 2963 2 NAND2X4_HS $T=207460 411240 0 180 $X=202220 $Y=406795
X13623 VSS: 2 VSS: 3176 3171 2 INVX4_HS $T=212060 411240 1 0 $X=211880 $Y=406795
X13629 VSS: 2 VSS: 2964 2961 2 INVX4_HS $T=204240 411240 1 180 $X=200840 $Y=410975
X13633 VSS: 2 VSS: 2965 2959 2 INVX2_HS $T=207460 411240 0 0 $X=207280 $Y=410975
X13636 VSS: 2 VSS: 1969 1364 3176 2 NAND2X4_HS $T=217580 411240 1 180 $X=212340 $Y=410975
X13637 VSS: 2 VSS: 2775 2966 2 CLKINVX2_HS $T=198720 419520 1 0 $X=198540 $Y=415075
X13641 VSS: 2 VSS: 2966 1364 2965 2 NAND2X2_HS $T=207460 419520 1 0 $X=207280 $Y=415075
X13647 VSS: 2 VSS: 1971 1364 2964 2 NAND2X4_HS $T=202860 419520 1 180 $X=197620 $Y=419255
X13649 VSS: 2 VSS: 2776 2956 2 INVX4_HS $T=209760 419520 1 180 $X=206360 $Y=419255
X13653 VSS: 2 VSS: 2537 2968 2967 2 NAND2X2_HS $T=204700 427800 0 180 $X=201300 $Y=423355
X13662 VSS: 2 VSS: rdata_o[5] 2572 2 BUFX2 $T=200100 427800 0 0 $X=199920 $Y=427535
X13667 VSS: 2 VSS: 2970 3180 2 BUFX4_HS $T=216200 427800 1 180 $X=212340 $Y=427535
X13669 VSS: 2 VSS: 2541 2596 2 BUFX2_HS $T=206080 436080 0 180 $X=203140 $Y=431635
X13676 VSS: 2 VSS: 2550 2542 2606 2808 2971 2 AOI22X1 $T=202860 436080 0 0 $X=202680 $Y=435815
X13690 VSS: 2 VSS: 1406 2972 2975 2973 2974 2 NAND4X4_HS $T=202860 444360 0 0 $X=202680 $Y=444095
X13696 VSS: 2 VSS: 2974 2978 2977 2976 2970 2 AOI22X2 $T=205160 452640 1 0 $X=204980 $Y=448195
X13702 VSS: 2 VSS: 2981 2979 2980 2 AND2X1_HS $T=201940 452640 0 0 $X=201760 $Y=452375
X13709 VSS: 2 VSS: 2980 2970 2982 2983 2978 2 AOI22X1_HS $T=208380 460920 0 180 $X=204980 $Y=456475
X13719 VSS: 2 VSS: 1150 2981 2984 2 NAND2X4_HS $T=204240 460920 0 0 $X=204060 $Y=460655
X13723 VSS: 2 VSS: 2987 2986 1988 2985 2779 2 NAND4X1 $T=201940 469200 1 0 $X=201760 $Y=464755
X13733 VSS: 2 VSS: 2972 2990 2989 2563 2988 2 AOI22X2 $T=207920 469200 1 180 $X=203140 $Y=468935
X13747 VSS: 2 VSS: 2985 2983 2991 2992 920 2 AOI22X1 $T=205620 477480 0 0 $X=205440 $Y=477215
X13756 VSS: 2 VSS: 2315 2543 3028 3029 3199 2 AOI22X1 $T=215740 485760 0 180 $X=212800 $Y=481315
X13764 VSS: 2 VSS: 2786 2977 2991 2992 1698 2 AOI22X1 $T=206540 485760 0 0 $X=206360 $Y=485495
X13778 VSS: 2 VSS: 2787 2993 2785 2796 1708 2 AOI22X1 $T=204240 494040 0 0 $X=204060 $Y=493775
X13784 VSS: 2 VSS: 2973 2995 2565 2993 2994 2 AOI22X2 $T=214820 502320 0 180 $X=210040 $Y=497875
X13790 VSS: 2 VSS: 2979 2994 2794 2781 2995 2 AOI22X1 $T=202400 502320 0 0 $X=202220 $Y=502055
X13801 VSS: 2 VSS: 929 2997 2 BUFX8 $T=212980 510600 1 180 $X=207740 $Y=510335
X13812 VSS: 2 VSS: 2999 2998 2991 2992 1172 2 AOI22X1 $T=207000 518880 0 0 $X=206820 $Y=518615
X13817 VSS: 2 VSS: 3000 3001 2326 2999 2793 2 NAND4X1 $T=206540 527160 1 0 $X=206360 $Y=522715
X13827 VSS: 2 VSS: 3001 3002 2785 2796 1178 2 AOI22X1 $T=206540 527160 0 0 $X=206360 $Y=526895
X13834 VSS: 2 VSS: 2798 3003 2991 2992 1428 2 AOI22X1 $T=209300 535440 1 0 $X=209120 $Y=530995
X13856 VSS: 2 VSS: 3006 3004 3005 2 AND2X1_HS $T=206080 552000 1 0 $X=205900 $Y=547555
X13864 VSS: 2 VSS: 1723 3007 3006 2 NAND2X4_HS $T=209300 552000 1 180 $X=204060 $Y=551735
X13877 VSS: 2 VSS: 3005 2994 3002 2580 2995 2 AOI22X1_HS $T=207000 560280 1 180 $X=203600 $Y=560015
X13891 VSS: 2 VSS: 3008 2995 2 CLKBUFX2 $T=206540 568560 0 0 $X=206360 $Y=568295
X13898 VSS: 2 VSS: 3009 3180 3216 3003 2978 2 AOI22X1_HS $T=215280 576840 0 180 $X=211880 $Y=572395
X13906 VSS: 2 VSS: 1735 3009 3010 2 CLKAND2X2 $T=212060 576840 0 0 $X=211880 $Y=576575
X13909 VSS: 2 VSS: 3010 2994 2795 2804 3008 2 AOI22X1_HS $T=208840 585120 0 180 $X=205440 $Y=580675
X13922 VSS: 2 VSS: 2033 2596 3011 3012 2595 2 AOI22X2_HS $T=206540 593400 1 0 $X=206360 $Y=588955
X13935 VSS: 2 VSS: 3013 2544 3012 3011 2546 2 AOI22X2_HS $T=209760 601680 0 180 $X=204060 $Y=597235
X13943 VSS: 2 VSS: 2040 3013 2 CLKBUFX2_HS $T=208840 601680 1 180 $X=205440 $Y=601415
X13950 VSS: 2 VSS: 3015 3008 2585 2801 2994 2 AOI22X2_HS $T=209760 609960 1 0 $X=209580 $Y=605515
X13959 VSS: 2 VSS: 3016 2988 2807 3219 2990 2 AOI22X1_HS $T=211600 609960 0 0 $X=211420 $Y=609695
X13964 VSS: 2 VSS: 1200 3016 3015 3014 2 NAND3X4_HS $T=212520 618240 0 180 $X=205440 $Y=613795
X13972 VSS: 2 VSS: 1209 7583 1914 2800 2 DFFX1_HS $T=197800 626520 1 0 $X=197620 $Y=622075
X13998 VSS: 2 VSS: 1482 3018 3017 2 NAND2X2_HS $T=206540 643080 0 180 $X=203140 $Y=638635
X14013 VSS: 2 VSS: 3020 2817 2345 2 NOR2X1 $T=217580 13800 0 0 $X=217400 $Y=13535
X14017 VSS: 2 VSS: 3019 3020 2 CLKBUFX2 $T=224480 13800 0 0 $X=224300 $Y=13535
X14022 VSS: 2 VSS: 3021 2814 2817 2 NOR2X1 $T=213900 22080 1 0 $X=213720 $Y=17635
X14026 VSS: 2 VSS: 3022 3021 2 CLKBUFX4 $T=222180 22080 1 0 $X=222000 $Y=17635
X14033 VSS: 2 VSS: 3023 2817 1634 2 OR2X1 $T=220340 22080 0 0 $X=220160 $Y=21815
X14040 VSS: 2 VSS: 3025 2816 2828 2 NOR2X1 $T=218500 30360 1 0 $X=218320 $Y=25915
X14043 VSS: 2 VSS: 3024 3025 2 CLKBUFX2 $T=224480 30360 1 0 $X=224300 $Y=25915
X14049 VSS: 2 VSS: 3205 3026 2 CLKBUFX4 $T=227700 30360 0 0 $X=227520 $Y=30095
X14053 VSS: 2 VSS: 3029 2821 2 CLKBUFX4 $T=213900 38640 1 0 $X=213720 $Y=34195
X14056 VSS: 2 VSS: 3028 3027 2 CLKBUFX4 $T=221260 38640 1 0 $X=221080 $Y=34195
X14061 VSS: 2 VSS: 3030 3023 2828 2 NOR2X1 $T=217580 38640 0 0 $X=217400 $Y=38375
X14065 VSS: 2 VSS: 3031 3030 2 CLKBUFX2 $T=227240 38640 0 0 $X=227060 $Y=38375
X14074 VSS: 2 VSS: 3033 3023 2822 2 NOR2X1 $T=223560 46920 1 0 $X=223380 $Y=42475
X14079 VSS: 2 VSS: 3035 2819 2345 2 NOR2X1 $T=218040 46920 0 0 $X=217860 $Y=46655
X14084 VSS: 2 VSS: 3034 3033 2 CLKBUFX2 $T=226780 46920 0 0 $X=226600 $Y=46655
X14092 VSS: 2 VSS: 3037 3036 2 CLKBUFX2 $T=220800 55200 1 0 $X=220620 $Y=50755
X14095 VSS: 2 VSS: 3198 3035 2 BUFX4_HS $T=227700 55200 1 0 $X=227520 $Y=50755
X14097 VSS: 2 VSS: 3038 2829 2 CLKBUFX2 $T=216200 55200 0 0 $X=216020 $Y=54935
X14100 VSS: 2 VSS: 3039 2827 2 CLKBUFX4 $T=224020 55200 0 0 $X=223840 $Y=54935
X14109 VSS: 2 VSS: 3040 3041 2 CLKBUFX2 $T=219880 63480 1 0 $X=219700 $Y=59035
X14114 VSS: 2 VSS: 3042 2832 2 CLKBUFX2 $T=216200 63480 0 0 $X=216020 $Y=63215
X14119 VSS: 2 VSS: 303 3235 2 BUFX16_HS $T=238740 63480 1 180 $X=228440 $Y=63215
X14128 VSS: 2 VSS: 3043 2833 2828 2 NOR2X1 $T=214360 71760 0 0 $X=214180 $Y=71495
X14132 VSS: 2 VSS: 3044 2833 2822 2 NOR2X1 $T=221260 71760 0 0 $X=221080 $Y=71495
X14135 VSS: 2 VSS: 3045 3043 2 CLKBUFX2 $T=227700 71760 0 0 $X=227520 $Y=71495
X14158 VSS: 2 VSS: 2312 3032 2 CLKBUFX4 $T=217580 88320 0 0 $X=217400 $Y=88055
X14161 VSS: 2 VSS: 3047 2830 2 CLKBUFX2 $T=223100 88320 0 0 $X=222920 $Y=88055
X14180 VSS: 2 VSS: 2842 3048 2 INVX2 $T=218960 104880 0 180 $X=217400 $Y=100435
X14197 VSS: 2 VSS: 2849 3049 3051 2 AND2X1 $T=216660 113160 1 180 $X=214180 $Y=112895
X14201 VSS: 2 VSS: 3048 3050 3051 2 AND2X1 $T=222180 113160 1 180 $X=219700 $Y=112895
X14209 VSS: 2 VSS: 2851 3052 3051 2 AND2X1 $T=218960 121440 0 180 $X=216480 $Y=116995
X14212 VSS: 2 VSS: 1795 3053 3051 2 AND2X1 $T=223560 121440 1 0 $X=223380 $Y=116995
X14216 VSS: 2 VSS: 2852 3055 2 INVX2 $T=216660 121440 1 180 $X=215100 $Y=121175
X14220 VSS: 2 VSS: 3055 3054 3051 2 AND2X1 $T=222180 121440 1 180 $X=219700 $Y=121175
X14232 VSS: 2 VSS: 2854 3057 2 INVX2 $T=217580 129720 1 180 $X=216020 $Y=129455
X14234 VSS: 2 VSS: 3057 3056 3051 2 AND2X1 $T=223560 129720 1 180 $X=221080 $Y=129455
X14241 VSS: 2 VSS: 2856 3058 2 INVX2 $T=217580 138000 0 180 $X=216020 $Y=133555
X14244 VSS: 2 VSS: 3058 3059 3051 2 AND2X1 $T=223100 138000 1 0 $X=222920 $Y=133555
X14256 VSS: 2 VSS: 2861 3060 2 INVX2 $T=215740 146280 0 180 $X=214180 $Y=141835
X14260 VSS: 2 VSS: 3051 1641 2 BUFX2 $T=223100 146280 0 180 $X=220620 $Y=141835
X14266 VSS: 2 VSS: 3060 3061 3051 2 AND2X1 $T=217580 146280 1 180 $X=215100 $Y=146015
X14277 VSS: 2 VSS: 3063 3062 1641 2 AND2X1 $T=224480 154560 0 180 $X=222000 $Y=150115
X14281 VSS: 2 VSS: 2867 3064 3051 2 AND2X1 $T=219420 154560 1 180 $X=216940 $Y=154295
X14291 VSS: 2 VSS: 3065 3067 2 INVX4_HS $T=223560 162840 1 0 $X=223380 $Y=158395
X14299 VSS: 2 VSS: 3072 509 2 CLKBUFX2 $T=231840 162840 1 180 $X=229360 $Y=162575
X14308 VSS: 2 VSS: 1846 3070 1641 2 AND2X1 $T=216200 171120 1 180 $X=213720 $Y=170855
X14313 VSS: 2 VSS: 2874 3066 3051 2 AND2X1 $T=223100 171120 0 0 $X=222920 $Y=170855
X14322 VSS: 2 VSS: 3071 wdata_i[4] 1641 1949 3072 2 AOI22X1 $T=225860 179400 1 0 $X=225680 $Y=174955
X14326 VSS: 2 VSS: 2451 3074 3051 2 AND2X1 $T=217120 179400 1 180 $X=214640 $Y=179135
X14331 VSS: 2 VSS: 3269 410 wdata_i[9] 2 CLKAND2X2 $T=228620 179400 0 0 $X=228440 $Y=179135
X14335 VSS: 2 VSS: 3069 3077 2 CLKINVX2 $T=213440 187680 1 0 $X=213260 $Y=183235
X14340 VSS: 2 VSS: 2681 3076 3051 2 AND2X1 $T=224020 187680 0 180 $X=221540 $Y=183235
X14354 VSS: 2 VSS: 3080 3081 1949 1641 wdata_i[9] 2 AOI22X1 $T=220340 195960 1 0 $X=220160 $Y=191515
X14358 VSS: 2 VSS: 3081 2938 2 CLKBUFX2 $T=231380 195960 0 180 $X=228900 $Y=191515
X14361 VSS: 2 VSS: 3082 1525 wdata_i[13] 2 CLKAND2X2 $T=216660 195960 0 0 $X=216480 $Y=195695
X14369 VSS: 2 VSS: 3085 2620 2355 2 NAND2X4 $T=214820 204240 1 0 $X=214640 $Y=199795
X14373 VSS: 2 VSS: 3083 3084 2 INVX4 $T=224940 204240 1 0 $X=224760 $Y=199795
X14377 VSS: 2 VSS: 3084 wdata_i[1] 1641 1949 2883 2 AOI22X1 $T=218040 204240 0 0 $X=217860 $Y=203975
X14385 VSS: 2 VSS: 2928 3085 2884 2 NAND2X4_HS $T=222180 212520 0 180 $X=216940 $Y=208075
X14388 VSS: 2 VSS: 3275 410 wdata_i[8] 2 CLKAND2X2 $T=229540 212520 1 0 $X=229360 $Y=208075
X14393 VSS: 2 VSS: 3088 410 wdata_i[1] 2 CLKAND2X2 $T=223100 212520 0 0 $X=222920 $Y=212255
X14403 VSS: 2 VSS: 2548 3089 1949 410 2897 2 AOI22X1 $T=221720 220800 1 0 $X=221540 $Y=216355
X14409 VSS: 2 VSS: 3091 wdata_i[8] 1641 1949 3090 2 AOI22X1 $T=219880 220800 0 0 $X=219700 $Y=220535
X14417 VSS: 2 VSS: 3090 2731 2 CLKBUFX2 $T=217120 229080 1 0 $X=216940 $Y=224635
X14422 VSS: 2 VSS: 3276 3278 1949 1641 wdata_i[14] 2 AOI22X1 $T=228160 229080 1 0 $X=227980 $Y=224635
X14426 VSS: 2 VSS: 3279 410 wdata_i[11] 2 CLKAND2X2 $T=229080 229080 0 0 $X=228900 $Y=228815
X14434 VSS: 2 VSS: 3097 3096 2 INVX2 $T=225860 237360 1 0 $X=225680 $Y=232915
X14440 VSS: 2 VSS: 3281 wdata_i[10] 1641 1949 3283 2 AOI22X1 $T=230920 237360 1 180 $X=227980 $Y=237095
X14448 VSS: 2 VSS: 3096 wdata_i[11] 1641 1949 3099 2 AOI22X1 $T=226780 245640 0 180 $X=223840 $Y=241195
X14455 VSS: 2 VSS: 3101 1525 wdata_i[16] 2 CLKAND2X2 $T=225860 245640 0 0 $X=225680 $Y=245375
X14461 VSS: 2 VSS: 3104 2896 1949 1641 wdata_i[16] 2 AOI22X1 $T=219880 253920 1 0 $X=219700 $Y=249475
X14467 VSS: 2 VSS: 3107 3105 1949 1525 3106 2 AOI22X1 $T=224020 253920 0 0 $X=223840 $Y=253655
X14474 VSS: 2 VSS: 2899 3108 2 CLKINVX1 $T=217580 262200 0 180 $X=216020 $Y=257755
X14478 VSS: 2 VSS: 3108 3106 1641 2 AND2X1 $T=222640 262200 1 0 $X=222460 $Y=257755
X14484 VSS: 2 VSS: 3109 wdata_i[15] 1525 2 AND2X1 $T=224480 262200 0 0 $X=224300 $Y=261935
X14490 VSS: 2 VSS: 1303 3111 2 BUFX8_HS $T=217120 270480 1 0 $X=216940 $Y=266035
X14495 VSS: 2 VSS: 3272 3112 2 INVX2 $T=229540 270480 1 0 $X=229360 $Y=266035
X14499 VSS: 2 VSS: 3112 wdata_i[15] 1641 1949 3113 2 AOI22X1 $T=222640 270480 0 0 $X=222460 $Y=270215
X14507 VSS: 2 VSS: 3113 2478 2 CLKBUFX2 $T=217580 278760 1 0 $X=217400 $Y=274315
X14509 VSS: 2 VSS: 3114 1525 wdata_i[12] 2 CLKAND2X2 $T=223560 278760 1 0 $X=223380 $Y=274315
X14515 VSS: 2 VSS: 3115 wdata_i[2] 1641 1949 3117 2 AOI22X1_HS $T=222180 278760 0 0 $X=222000 $Y=278495
X14523 VSS: 2 VSS: 117 3119 1641 2 AND2X1 $T=223100 287040 0 180 $X=220620 $Y=282595
X14528 VSS: 2 VSS: 2914 303 2 INVX4 $T=218040 287040 1 180 $X=215560 $Y=286775
X14531 VSS: 2 VSS: 3117 1306 2 CLKBUFX2 $T=220340 287040 0 0 $X=220160 $Y=286775
X14534 VSS: 2 VSS: 3122 3120 2 CLKINVX2 $T=226780 287040 0 0 $X=226600 $Y=286775
X14543 VSS: 2 VSS: 3120 wdata_i[3] 1641 1949 3123 2 AOI22X1_HS $T=225400 295320 1 0 $X=225220 $Y=290875
X14548 VSS: 2 VSS: 3123 840 2 CLKBUFX2 $T=224940 295320 0 0 $X=224760 $Y=295055
X14555 VSS: 2 VSS: 3125 303 2 INVX2 $T=216660 303600 1 0 $X=216480 $Y=299155
X14561 VSS: 2 VSS: 1065 3134 1641 2 AND2X1 $T=230920 303600 0 180 $X=228440 $Y=299155
X14565 VSS: 2 VSS: 3127 2938 2439 2 XOR2X1_HS $T=226780 303600 1 180 $X=222460 $Y=303335
X14572 VSS: 2 VSS: 2762 3129 2 CLKINVX4_HS $T=224940 311880 0 180 $X=218320 $Y=307435
X14575 VSS: 2 VSS: 3293 3292 1949 1641 wdata_i[6] 2 AOI22X1 $T=229080 311880 1 0 $X=228900 $Y=307435
X14578 VSS: 2 VSS: 3133 3132 3131 2 NOR2X2_HS $T=219880 311880 1 180 $X=216480 $Y=311615
X14581 VSS: 2 VSS: 3132 2761 2737 2 XOR2X1_HS $T=229540 311880 1 180 $X=225220 $Y=311615
X14590 VSS: 2 VSS: 1919 3135 1641 2 AND2X1 $T=223560 320160 0 180 $X=221080 $Y=315715
X14593 VSS: 2 VSS: 3295 2885 1525 1949 3294 2 AOI22X2 $T=229080 320160 1 0 $X=228900 $Y=315715
X14598 VSS: 2 VSS: 3138 3137 2 INVX2_HS $T=227240 320160 0 0 $X=227060 $Y=319895
X14605 VSS: 2 VSS: 2739 2478 3139 2912 2 OAI21X2_HS $T=224480 328440 0 180 $X=219700 $Y=323995
X14611 VSS: 2 VSS: 3139 2478 2912 2 NAND2X2 $T=224940 328440 1 180 $X=222460 $Y=328175
X14618 VSS: 2 VSS: 3136 3118 2929 3140 2 NOR3X2_HS $T=213440 336720 1 0 $X=213260 $Y=332275
X14622 VSS: 2 VSS: 3292 1117 2 CLKBUFX2 $T=229080 336720 1 0 $X=228900 $Y=332275
X14624 VSS: 2 VSS: 2931 1097 2 CLKINVX2 $T=216200 336720 1 180 $X=214640 $Y=336455
X14627 VSS: 2 VSS: 3143 3141 2 CLKINVX2 $T=221720 336720 1 180 $X=220160 $Y=336455
X14630 VSS: 2 VSS: 3142 3105 2 INVX2_HS $T=226780 336720 1 180 $X=224300 $Y=336455
X14637 VSS: 2 VSS: 3140 1117 426 2 XOR2X1_HS $T=218960 345000 0 180 $X=214640 $Y=340555
X14641 VSS: 2 VSS: 3144 3142 2951 2 NOR2X1 $T=224020 345000 1 0 $X=223840 $Y=340555
X14647 VSS: 2 VSS: 3146 3145 1147 2 OR2X1_HS $T=222640 345000 1 180 $X=219700 $Y=344735
X14651 VSS: 2 VSS: 3147 3144 2 INVX1 $T=225860 345000 0 0 $X=225680 $Y=344735
X14657 VSS: 2 VSS: 2747 3146 3148 2 NAND2X2_HS $T=219880 353280 0 180 $X=216480 $Y=348835
X14660 VSS: 2 VSS: 3149 2939 2 BUFX8_HS $T=222640 353280 1 0 $X=222460 $Y=348835
X14664 VSS: 2 VSS: 3148 3150 2282 2 NAND2X1 $T=219880 353280 1 180 $X=217860 $Y=353015
X14667 VSS: 2 VSS: 2939 1362 3147 2 NOR2X2_HS $T=227240 353280 1 180 $X=223840 $Y=353015
X14674 VSS: 2 VSS: 2940 3151 3152 1147 2 OAI21X1_HS $T=221720 361560 0 180 $X=218780 $Y=357115
X14678 VSS: 2 VSS: 3153 3138 2951 2 NOR2X1 $T=227700 361560 1 0 $X=227520 $Y=357115
X14680 VSS: 2 VSS: 2941 3156 3157 2 NAND2X2_HS $T=218040 361560 1 180 $X=214640 $Y=361295
X14682 VSS: 2 VSS: 3156 1147 3154 2 OR2X1_HS $T=224480 361560 1 180 $X=221540 $Y=361295
X14689 VSS: 2 VSS: 3152 3155 2282 2 NAND2X1 $T=221720 369840 0 180 $X=219700 $Y=365395
X14692 VSS: 2 VSS: 3099 2273 2 CLKBUFX2 $T=228160 369840 0 180 $X=225680 $Y=365395
X14696 VSS: 2 VSS: 3157 3158 2282 2 NAND2X1 $T=221720 369840 1 180 $X=219700 $Y=369575
X14699 VSS: 2 VSS: 3158 1364 3153 2 AND2X2 $T=229080 369840 0 0 $X=228900 $Y=369575
X14705 VSS: 2 VSS: 2948 2755 3159 2 AND2X1_HS $T=217580 378120 0 180 $X=214640 $Y=373675
X14707 VSS: 2 VSS: 3161 3160 2 INVX1 $T=221260 378120 1 0 $X=221080 $Y=373675
X14710 VSS: 2 VSS: 3162 3161 2 INVX1 $T=224940 378120 1 0 $X=224760 $Y=373675
X14714 VSS: 2 VSS: 3160 w_en_i 1641 1949 1648 2 AOI22X1 $T=219420 378120 1 180 $X=216480 $Y=377855
X14718 VSS: 2 VSS: 3311 3134 410 1949 3174 2 AOI22X2 $T=227700 378120 0 0 $X=227520 $Y=377855
X14726 VSS: 2 VSS: 3164 2951 3163 2 NOR2X2_HS $T=221260 386400 1 0 $X=221080 $Y=381955
X14731 VSS: 2 VSS: 3165 3164 2 CLKINVX2 $T=220800 386400 0 0 $X=220620 $Y=386135
X14736 VSS: 2 VSS: 3312 3313 2 BUFX8 $T=234140 386400 1 180 $X=228900 $Y=386135
X14741 VSS: 2 VSS: 2954 1641 3166 2 NAND2X4_HS $T=219880 394680 0 180 $X=214640 $Y=390235
X14744 VSS: 2 VSS: 3167 1362 3165 2 NOR2X2_HS $T=227700 394680 0 180 $X=224300 $Y=390235
X14748 VSS: 2 VSS: 2281 3167 2 CLKINVX1 $T=221260 394680 1 180 $X=219700 $Y=394415
X14751 VSS: 2 VSS: 3168 2951 2 INVX2 $T=225860 394680 0 0 $X=225680 $Y=394415
X14754 VSS: 2 VSS: 3315 2951 2 INVX2 $T=229540 394680 0 0 $X=229360 $Y=394415
X14760 VSS: 2 VSS: 3171 2755 3169 2 NAND2X4_HS $T=216200 402960 1 0 $X=216020 $Y=398515
X14763 VSS: 2 VSS: 3177 3168 3170 2 NAND2X4_HS $T=225860 402960 1 0 $X=225680 $Y=398515
X14768 VSS: 2 VSS: 2531 1364 3172 2 NAND2X4_HS $T=226780 402960 1 180 $X=221540 $Y=402695
X14775 VSS: 2 VSS: 3175 2755 3174 2 NAND2X4_HS $T=216660 411240 1 0 $X=216480 $Y=406795
X14779 VSS: 2 VSS: 3173 3318 2 BUFX8 $T=232760 411240 0 180 $X=227520 $Y=406795
X14782 VSS: 2 VSS: 3178 3177 2 CLKINVX1_HS $T=227700 411240 1 180 $X=224760 $Y=410975
X14788 VSS: 2 VSS: 3179 3175 2 INVX2_HS $T=220340 419520 0 180 $X=217860 $Y=415075
X14795 VSS: 2 VSS: 1383 1364 3179 2 NAND2X2_HS $T=217120 419520 1 180 $X=213720 $Y=419255
X14799 VSS: 2 VSS: 694 1364 3178 2 AND2X2_HS $T=226780 419520 1 180 $X=223380 $Y=419255
X14806 VSS: 2 VSS: 2967 2971 3017 2 NAND2X2_HS $T=223100 427800 0 180 $X=219700 $Y=423355
X14810 VSS: 2 VSS: 3321 3158 2 BUFX8_HS $T=229080 427800 1 0 $X=228900 $Y=423355
X14816 VSS: 2 VSS: 2273 3322 2 BUFX8_HS $T=232300 427800 1 180 $X=226600 $Y=427535
X14824 VSS: 2 VSS: 2968 3182 3181 2 NAND2X4 $T=227700 436080 0 180 $X=223380 $Y=431635
X14829 VSS: 2 VSS: 2562 2539 3183 2808 3184 2 AOI22X1 $T=227240 436080 1 180 $X=224300 $Y=435815
X14835 VSS: 2 VSS: 2777 3181 3184 3185 3017 2 AOI22X2_HS $T=222180 444360 0 180 $X=216480 $Y=439915
X14851 VSS: 2 VSS: 927 3323 2 BUFX8_HS $T=232300 452640 0 180 $X=226600 $Y=448195
X14854 VSS: 2 VSS: 2990 3186 2 BUFX8_HS $T=226780 452640 1 180 $X=221080 $Y=452375
X14863 VSS: 2 VSS: 2984 3187 3188 2 CLKAND2X2 $T=227240 460920 0 180 $X=224760 $Y=456475
X14868 VSS: 2 VSS: 3187 2988 2554 3189 2990 2 AOI22X1_HS $T=224940 460920 0 0 $X=224760 $Y=460655
X14876 VSS: 2 VSS: 3191 3189 2554 3192 3190 2 AOI22X1_HS $T=224940 469200 1 0 $X=224760 $Y=464755
X14880 VSS: 2 VSS: 2310 3191 3194 3193 3325 2 NAND4X4_HS $T=222640 469200 0 0 $X=222460 $Y=468935
X14886 VSS: 2 VSS: 3194 3195 2794 2781 3196 2 AOI22X2 $T=216200 477480 1 0 $X=216020 $Y=473035
X14895 VSS: 2 VSS: 1996 2982 3039 3198 3197 2 AOI22X1 $T=226320 477480 0 0 $X=226140 $Y=477215
X14904 VSS: 2 VSS: 2314 3182 3022 3205 3189 2 AOI22X1 $T=227700 485760 1 0 $X=227520 $Y=481315
X14909 VSS: 2 VSS: 3200 2989 2563 3192 3190 2 AOI22X1_HS $T=225400 485760 0 0 $X=225220 $Y=485495
X14915 VSS: 2 VSS: 1689 3203 3200 3202 3201 2 NAND4X4_HS $T=214820 494040 1 0 $X=214640 $Y=489595
X14922 VSS: 2 VSS: 3202 3195 2993 2565 3196 2 AOI22X1 $T=224480 494040 0 0 $X=224300 $Y=493775
X14935 VSS: 2 VSS: 1692 3204 2 BUFX16_HS $T=230460 502320 1 180 $X=220160 $Y=502055
X14943 VSS: 2 VSS: 2011 3185 3022 3205 2989 2 AOI22X1 $T=227700 510600 0 180 $X=224760 $Y=506155
X14950 VSS: 2 VSS: 2003 2976 3039 3198 3206 2 AOI22X1 $T=227240 510600 0 0 $X=227060 $Y=510335
X14960 VSS: 2 VSS: 3203 3327 2977 2976 3329 2 AOI22X2 $T=233220 518880 0 180 $X=228440 $Y=514435
X14973 VSS: 2 VSS: 2993 7584 1893 3207 2 DFFX1_HS $T=223560 527160 1 0 $X=223380 $Y=522715
X14975 VSS: 2 VSS: 939 3208 2 INVX8_HS $T=217120 527160 0 0 $X=216940 $Y=526895
X14978 VSS: 2 VSS: 2794 7585 2018 3207 2 DFFX1_HS $T=226320 527160 0 0 $X=226140 $Y=526895
X14984 VSS: 2 VSS: 3002 7586 2015 3207 2 DFFX1_HS $T=223100 535440 1 0 $X=222920 $Y=530995
X14986 VSS: 2 VSS: 2575 3209 2991 2992 936 2 AOI22X1 $T=215280 535440 0 0 $X=215100 $Y=535175
X14999 VSS: 2 VSS: 3331 3327 2998 3210 3329 2 AOI22X2_HS $T=233680 543720 0 180 $X=227980 $Y=539275
X15001 VSS: 2 VSS: 3004 2978 2998 3210 3180 2 AOI22X2_HS $T=220340 543720 1 180 $X=214640 $Y=543455
X15016 VSS: 2 VSS: 3211 3212 3213 2 AND2X1_HS $T=225400 552000 0 0 $X=225220 $Y=551735
X15022 VSS: 2 VSS: 3213 3196 2580 3002 3195 2 AOI22X2_HS $T=225860 560280 0 180 $X=220160 $Y=555835
X15029 VSS: 2 VSS: 3333 3327 3209 3214 3330 2 AOI22X2_HS $T=234600 560280 1 180 $X=228900 $Y=560015
X15035 VSS: 2 VSS: 3215 2978 3209 3214 3180 2 AOI22X2_HS $T=226320 568560 0 180 $X=220620 $Y=564115
X15041 VSS: 2 VSS: 3334 3327 3003 3216 3330 2 AOI22X2_HS $T=233680 568560 1 180 $X=227980 $Y=568295
X15063 VSS: 2 VSS: 3337 3196 2804 2795 3195 2 AOI22X2 $T=229540 585120 1 0 $X=229360 $Y=580675
X15064 VSS: 2 VSS: 2582 3011 2606 2808 3217 2 AOI22X1 $T=216660 585120 1 180 $X=213720 $Y=584855
X15077 VSS: 2 VSS: 3218 3196 3195 2801 2585 2 AOI22X2 $T=217120 593400 0 0 $X=216940 $Y=593135
X15116 VSS: 2 VSS: 3014 3220 3215 2 AND2X2_HS $T=224480 618240 1 180 $X=221080 $Y=617975
X15126 VSS: 2 VSS: 3221 3192 2807 3219 3190 2 AOI22X1_HS $T=224020 626520 1 0 $X=223840 $Y=622075
X15129 VSS: 2 VSS: 2590 2597 2606 2808 3018 2 AOI22X1 $T=216200 626520 0 0 $X=216020 $Y=626255
X15141 VSS: 2 VSS: 1476 3218 3221 3344 3333 2 NAND4X4_HS $T=224940 634800 1 0 $X=224760 $Y=630355
X15142 VSS: 2 VSS: 2594 2602 2606 2808 3222 2 AOI22X1 $T=217120 634800 1 180 $X=214180 $Y=634535
X15163 VSS: 2 VSS: 3225 2809 2 CLKBUFX2 $T=230460 13800 0 0 $X=230280 $Y=13535
X15168 VSS: 2 VSS: 3223 3224 1206 2 NAND2X1_HS $T=241500 13800 0 0 $X=241320 $Y=13535
X15170 VSS: 2 VSS: 3226 2813 2 CLKBUFX2 $T=230460 22080 1 0 $X=230280 $Y=17635
X15199 VSS: 2 VSS: 3230 2823 2 CLKBUFX2 $T=233220 46920 1 0 $X=233040 $Y=42475
X15207 VSS: 2 VSS: 3228 3231 1206 2 NAND2X1 $T=243340 46920 1 180 $X=241320 $Y=46655
X15215 VSS: 2 VSS: 3233 3227 3232 2 NOR2X2_HS $T=238280 55200 1 180 $X=234880 $Y=54935
X15221 VSS: 2 VSS: 3235 3234 3233 2 NAND2X2_HS $T=232760 63480 1 0 $X=232580 $Y=59035
X15229 VSS: 2 VSS: 3234 3237 3236 2 NOR2X2_HS $T=232300 71760 1 0 $X=232120 $Y=67315
X15236 VSS: 2 VSS: 3238 3044 2 CLKBUFX2 $T=233220 71760 0 0 $X=233040 $Y=71495
X15245 VSS: 2 VSS: 3240 3229 3239 2 NOR2X2_HS $T=233680 80040 0 0 $X=233500 $Y=79775
X15250 VSS: 2 VSS: 3232 3241 3242 3244 3243 2 NAND4X2_HS $T=234140 88320 1 0 $X=233960 $Y=83875
X15256 VSS: 2 VSS: 3111 3240 3245 2 NAND2X4_HS $T=238740 88320 0 0 $X=238560 $Y=88055
X15262 VSS: 2 VSS: 3243 3247 3246 3248 918 2 AOI22X2_HS $T=242880 96600 0 180 $X=237180 $Y=92155
X15269 VSS: 2 VSS: 3374 3247 3249 3384 918 2 AOI22X2_HS $T=249320 96600 1 180 $X=243620 $Y=96335
X15277 VSS: 2 VSS: 3254 3251 3250 3253 3252 2 NAND4X2_HS $T=242880 104880 1 180 $X=237180 $Y=104615
X15282 VSS: 2 VSS: 3252 3247 3255 3256 918 2 AOI22X2 $T=242420 113160 0 180 $X=237640 $Y=108715
X15291 VSS: 2 VSS: 3258 3257 3254 2 NOR2X2_HS $T=238280 121440 1 0 $X=238100 $Y=116995
X15306 VSS: 2 VSS: 3260 3258 3259 2 NAND2X2_HS $T=241960 129720 1 180 $X=238560 $Y=129455
X15311 VSS: 2 VSS: 2731 3260 2 BUFX8_HS $T=236900 138000 1 0 $X=236720 $Y=133555
X15314 VSS: 2 VSS: 3261 303 2 BUFX2_HS $T=232760 138000 0 0 $X=232580 $Y=137735
X15318 VSS: 2 VSS: 2654 3262 1641 2 AND2X1 $T=232300 146280 0 180 $X=229820 $Y=141835
X15323 VSS: 2 VSS: 2142 3263 1641 2 AND2X1 $T=243800 146280 1 0 $X=243620 $Y=141835
X15327 VSS: 2 VSS: 3266 3264 1949 1641 wdata_i[5] 2 AOI22X1_HS $T=240120 146280 0 0 $X=239940 $Y=146015
X15330 VSS: 2 VSS: 1818 3267 1641 2 AND2X1 $T=232760 154560 0 180 $X=230280 $Y=150115
X15343 VSS: 2 VSS: 3270 3071 2 INVX2 $T=230920 171120 0 0 $X=230740 $Y=170855
X15352 VSS: 2 VSS: 3273 1525 wdata_i[4] 2 CLKAND2X2 $T=230920 187680 1 0 $X=230740 $Y=183235
X15355 VSS: 2 VSS: 3274 3080 2 INVX2 $T=230000 187680 0 0 $X=229820 $Y=187415
X15367 VSS: 2 VSS: 3268 410 wdata_i[14] 2 CLKAND2X2 $T=230460 204240 0 0 $X=230280 $Y=203975
X15375 VSS: 2 VSS: 3271 3276 2 INVX2 $T=232300 212520 0 0 $X=232120 $Y=212255
X15382 VSS: 2 VSS: 3277 3091 2 INVX2 $T=232760 220800 0 0 $X=232580 $Y=220535
X15390 VSS: 2 VSS: 3280 410 wdata_i[10] 2 CLKAND2X2 $T=231840 237360 1 0 $X=231660 $Y=232915
X15393 VSS: 2 VSS: 3282 3281 2 INVX2 $T=234600 237360 0 0 $X=234420 $Y=237095
X15396 VSS: 2 VSS: 3283 2919 2 CLKBUFX2 $T=235060 245640 0 180 $X=232580 $Y=241195
X15402 VSS: 2 VSS: 3284 3104 2 INVX4 $T=231380 253920 1 0 $X=231200 $Y=249475
X15407 VSS: 2 VSS: 3285 3107 2 BUFX2 $T=232760 253920 0 0 $X=232580 $Y=253655
X15418 VSS: 2 VSS: 3287 3115 2 INVX2 $T=231380 278760 1 0 $X=231200 $Y=274315
X15420 VSS: 2 VSS: 3286 2761 2 CLKBUFX2 $T=233680 278760 1 0 $X=233500 $Y=274315
X15421 VSS: 2 VSS: 3278 2504 2 CLKBUFX2 $T=235060 278760 1 180 $X=232580 $Y=278495
X15424 VSS: 2 VSS: 3288 1525 wdata_i[2] 2 CLKAND2X2 $T=231380 287040 1 0 $X=231200 $Y=282595
X15428 VSS: 2 VSS: 3289 410 wdata_i[3] 2 CLKAND2X2 $T=232300 287040 0 0 $X=232120 $Y=286775
X15434 VSS: 2 VSS: 3264 1097 2 BUFX2 $T=232300 295320 0 0 $X=232120 $Y=295055
X15442 VSS: 2 VSS: 3290 410 wdata_i[6] 2 CLKAND2X2 $T=232760 303600 0 0 $X=232580 $Y=303335
X15446 VSS: 2 VSS: 3291 3293 2 INVX2 $T=234140 311880 1 0 $X=233960 $Y=307435
X15453 VSS: 2 VSS: 3297 3296 2 INVX2_HS $T=234140 320160 1 180 $X=231660 $Y=319895
X15456 VSS: 2 VSS: 3298 2963 1949 1525 3119 2 AOI22X1 $T=232300 328440 1 0 $X=232120 $Y=323995
X15458 VSS: 2 VSS: 3299 3294 2 INVX2_HS $T=230000 328440 0 0 $X=229820 $Y=328175
X15461 VSS: 2 VSS: 3301 3300 2 INVX2 $T=233220 336720 1 0 $X=233040 $Y=332275
X15466 VSS: 2 VSS: 3300 w_en_i 410 2 AND2X1 $T=234140 336720 1 180 $X=231660 $Y=336455
X15468 VSS: 2 VSS: 3302 2951 3299 2 NOR2X2_HS $T=230000 345000 1 0 $X=229820 $Y=340555
X15470 VSS: 2 VSS: 3303 3298 2 BUFX2 $T=233680 345000 1 0 $X=233500 $Y=340555
X15472 VSS: 2 VSS: 3304 3302 2 CLKINVX2 $T=231840 345000 0 0 $X=231660 $Y=344735
X15476 VSS: 2 VSS: 3305 3150 2 BUFX8_HS $T=230460 353280 1 0 $X=230280 $Y=348835
X15477 VSS: 2 VSS: 3150 1362 3304 2 NOR2X2_HS $T=230920 353280 0 0 $X=230740 $Y=353015
X15480 VSS: 2 VSS: 3306 3297 2951 2 NOR2X1 $T=231840 361560 1 0 $X=231660 $Y=357115
X15484 VSS: 2 VSS: 3155 1364 3306 2 AND2X2 $T=232760 361560 1 180 $X=230280 $Y=361295
X15488 VSS: 2 VSS: 3307 3170 1949 410 3135 2 AOI22X1 $T=231840 369840 1 0 $X=231660 $Y=365395
X15494 VSS: 2 VSS: 3308 3309 1949 410 2887 2 AOI22X1 $T=230460 378120 1 0 $X=230280 $Y=373675
X15496 VSS: 2 VSS: 3310 3308 2 BUFX2 $T=233680 378120 1 0 $X=233500 $Y=373675
X15499 VSS: 2 VSS: 3163 3309 2 INVX2_HS $T=232760 386400 0 180 $X=230280 $Y=381955
X15506 VSS: 2 VSS: 3316 3315 3314 2 NAND2X4_HS $T=230920 394680 0 0 $X=230740 $Y=394415
X15509 VSS: 2 VSS: 3317 3307 2 BUFX2 $T=233680 402960 1 0 $X=233500 $Y=398515
X15512 VSS: 2 VSS: 3172 3316 2 INVX2_HS $T=234140 402960 1 180 $X=231660 $Y=402695
X15519 VSS: 2 VSS: 3319 3167 2 BUFX8_HS $T=230000 419520 1 0 $X=229820 $Y=415075
X15521 VSS: 2 VSS: 3320 3155 2 BUFX8_HS $T=230460 419520 0 0 $X=230280 $Y=419255
X15538 VSS: 2 VSS: 2778 3324 2 CLKBUFX8 $T=235980 460920 0 180 $X=230740 $Y=456475
X15559 VSS: 2 VSS: 2309 3328 2 BUFX4_HS $T=233680 502320 0 180 $X=229820 $Y=497875
X15580 VSS: 2 VSS: 3325 3327 2983 2982 3330 2 AOI22X2_HS $T=230000 518880 0 0 $X=229820 $Y=518615
X15596 VSS: 2 VSS: 2801 7587 1914 3207 2 DFFX1_HS $T=242880 535440 1 0 $X=242700 $Y=530995
X15599 VSS: 2 VSS: 2795 7588 1561 3207 2 DFFX1_HS $T=232300 535440 0 0 $X=232120 $Y=535175
X15611 VSS: 2 VSS: 708 3332 3331 3211 2 NAND3X4_HS $T=238280 552000 0 180 $X=231200 $Y=547555
X15620 VSS: 2 VSS: 2027 3210 3039 3198 3405 2 AOI22X1 $T=247940 552000 1 180 $X=245000 $Y=551735
X15640 VSS: 2 VSS: 2044 3216 3039 3198 3335 2 AOI22X1 $T=235060 576840 0 180 $X=232120 $Y=572395
X15646 VSS: 2 VSS: 3212 3190 3336 2803 3192 2 AOI22X2_HS $T=240120 576840 0 0 $X=239940 $Y=576575
X15654 VSS: 2 VSS: 1739 3214 3039 3198 3338 2 AOI22X1 $T=235520 585120 1 180 $X=232580 $Y=584855
X15663 VSS: 2 VSS: 2039 3411 2 BUFX8_HS $T=249780 593400 0 180 $X=244080 $Y=588955
X15670 VSS: 2 VSS: 1467 3337 3339 3340 3334 2 NAND4X4_HS $T=235980 601680 1 0 $X=235800 $Y=597235
X15680 VSS: 2 VSS: 1734 3341 3342 2 CLKAND2X2 $T=237360 609960 0 180 $X=234880 $Y=605515
X15686 VSS: 2 VSS: 3342 2990 3343 2805 2988 2 AOI22X2_HS $T=237360 609960 0 0 $X=237180 $Y=609695
X15692 VSS: 2 VSS: 3339 3190 3192 2805 3343 2 AOI22X2 $T=245180 618240 0 180 $X=240400 $Y=613795
X15715 VSS: 2 VSS: 1214 3345 2 BUFX4_HS $T=243340 634800 1 180 $X=239480 $Y=634535
X15719 VSS: 2 VSS: 2342 3181 3017 3346 3222 2 AOI22X2_HS $T=242420 643080 0 180 $X=236720 $Y=638635
X15722 VSS: 2 VSS: 3348 3347 3223 2 AND2X1_HS $T=247480 13800 1 0 $X=247300 $Y=9355
X15735 VSS: 2 VSS: 3349 3224 3350 2 NAND2X1 $T=257140 13800 0 0 $X=256960 $Y=13535
X15749 VSS: 2 VSS: 3353 3348 3352 3351 2 NAND3X2_HS $T=248860 22080 0 0 $X=248680 $Y=21815
X15757 VSS: 2 VSS: 3352 3356 3357 3354 3355 2 AOI22X2_HS $T=253460 30360 0 180 $X=247760 $Y=25915
X15766 VSS: 2 VSS: 3360 3356 3355 3359 3358 2 AOI22X2 $T=253000 30360 1 180 $X=248220 $Y=30095
X15775 VSS: 2 VSS: 3227 3360 3362 3228 3361 2 NAND4X2_HS $T=247480 38640 1 0 $X=247300 $Y=34195
X15786 VSS: 2 VSS: 3363 3173 3359 3358 3364 2 AOI22X2_HS $T=254840 38640 0 0 $X=254660 $Y=38375
X15795 VSS: 2 VSS: 3229 3367 3365 3363 3366 2 NAND4X2_HS $T=255300 46920 1 0 $X=255120 $Y=42475
X15805 VSS: 2 VSS: 3365 3231 3350 2 NAND2X1 $T=255760 46920 0 0 $X=255580 $Y=46655
X15814 VSS: 2 VSS: 3370 3368 3369 2 NOR2X2_HS $T=253920 55200 1 0 $X=253740 $Y=50755
X15822 VSS: 2 VSS: 509 3371 2 BUFX8_HS $T=252080 55200 0 0 $X=251900 $Y=54935
X15833 VSS: 2 VSS: 3371 3370 3372 2 NAND2X1_HS $T=256220 63480 0 180 $X=253740 $Y=59035
X15842 VSS: 2 VSS: 3372 3373 3353 2 NOR2X1_HS $T=253920 63480 0 0 $X=253740 $Y=63215
X15850 VSS: 2 VSS: 3373 3376 3377 3375 3374 2 NAND4X1_HS $T=253920 71760 1 0 $X=253740 $Y=67315
X15859 VSS: 2 VSS: 3375 1149 3379 126 3378 2 AOI22X2_HS $T=255300 71760 1 180 $X=249600 $Y=71495
X15876 VSS: 2 VSS: 3241 1149 3381 3380 3379 2 AOI22X2_HS $T=260360 80040 1 180 $X=254660 $Y=79775
X15894 VSS: 2 VSS: 3251 3383 3382 3379 1149 2 AOI22X1_HS $T=260360 88320 1 180 $X=256960 $Y=88055
X15925 VSS: 2 VSS: 3385 2778 2 CLKBUFX4 $T=253000 104880 0 0 $X=252820 $Y=104615
X15941 VSS: 2 VSS: 3257 3387 3388 3386 2 NAND3X2_HS $T=250240 113160 0 0 $X=250060 $Y=112895
X15957 VSS: 2 VSS: 3388 3356 3355 3390 3389 2 AOI22X2 $T=253920 121440 1 180 $X=249140 $Y=121175
X15965 VSS: 2 VSS: 3391 3364 3389 3390 3173 2 AOI22X2_HS $T=253920 129720 0 180 $X=248220 $Y=125275
X15976 VSS: 2 VSS: 3387 3392 3393 2 AND2X1_HS $T=258520 129720 1 180 $X=255580 $Y=129455
X15987 VSS: 2 VSS: 3392 3394 1206 2 NAND2X1 $T=258520 138000 0 180 $X=256500 $Y=133555
X15997 VSS: 2 VSS: 3396 3395 2 BUFX4_HS $T=255760 138000 0 0 $X=255580 $Y=137735
X16004 VSS: 2 VSS: 3395 1145 2 CLKBUFX2 $T=250240 146280 1 0 $X=250060 $Y=141835
X16007 VSS: 2 VSS: 2547 3397 2 CLKBUFX8 $T=259900 146280 0 180 $X=254660 $Y=141835
X16016 VSS: 2 VSS: 3451 3266 2 INVX4 $T=261740 146280 0 0 $X=261560 $Y=146015
X16113 VSS: 2 VSS: 3400 3318 2 BUFX8_HS $T=252540 502320 1 180 $X=246840 $Y=502055
X16120 VSS: 2 VSS: 3193 3401 3197 3199 3326 2 AOI22X2_HS $T=251620 510600 0 180 $X=245920 $Y=506155
X16131 VSS: 2 VSS: 3201 3401 3206 3402 3453 2 AOI22X2_HS $T=261280 510600 0 0 $X=261100 $Y=510335
X16146 VSS: 2 VSS: 2008 2540 3028 3029 3402 2 AOI22X1 $T=258980 518880 1 180 $X=256040 $Y=518615
X16151 VSS: 2 VSS: 3188 3399 3199 3197 3403 2 AOI22X1 $T=250240 527160 0 180 $X=247300 $Y=522715
X16163 VSS: 2 VSS: 2975 3403 3206 3402 3399 2 AOI22X2 $T=256220 527160 1 180 $X=251440 $Y=526895
X16188 VSS: 2 VSS: 426 3456 2 BUFX16_HS $T=269100 543720 0 180 $X=258800 $Y=539275
X16194 VSS: 2 VSS: 3332 3401 3326 3404 3405 2 AOI22X2_HS $T=256220 543720 1 180 $X=250520 $Y=543455
X16217 VSS: 2 VSS: 3406 3399 3404 3405 3403 2 AOI22X1_HS $T=256680 560280 0 180 $X=253280 $Y=555835
X16225 VSS: 2 VSS: 3007 3406 3407 2 AND2X2_HS $T=257140 560280 1 180 $X=253740 $Y=560015
X16235 VSS: 2 VSS: 3407 2988 2803 3336 2990 2 AOI22X1_HS $T=260360 568560 0 180 $X=256960 $Y=564115
X16245 VSS: 2 VSS: 2329 3012 3028 3029 3404 2 AOI22X1 $T=259900 568560 1 180 $X=256960 $Y=568295
X16253 VSS: 2 VSS: 2331 3408 3022 3205 3336 2 AOI22X1 $T=252080 576840 1 0 $X=251900 $Y=572395
X16271 VSS: 2 VSS: 3410 3409 3217 3408 3400 2 AOI22X2_HS $T=259440 585120 0 180 $X=253740 $Y=580675
X16278 VSS: 2 VSS: 2032 3410 2 BUFX8_HS $T=253920 585120 0 0 $X=253740 $Y=584855
X16292 VSS: 2 VSS: 3411 3181 3217 3408 3017 2 AOI22X2_HS $T=254380 593400 1 180 $X=248680 $Y=593135
X16306 VSS: 2 VSS: 3340 3401 3335 3412 3326 2 AOI22X2_HS $T=252080 601680 1 180 $X=246380 $Y=601415
X16315 VSS: 2 VSS: 3341 3399 3412 3335 3403 2 AOI22X1 $T=256680 609960 0 180 $X=253740 $Y=605515
X16340 VSS: 2 VSS: 2338 3346 3022 3205 3219 2 AOI22X1 $T=249320 618240 0 0 $X=249140 $Y=617975
X16348 VSS: 2 VSS: 3220 3399 3413 3338 3403 2 AOI22X1 $T=250700 626520 0 180 $X=247760 $Y=622075
X16357 VSS: 2 VSS: 3344 3326 3413 3338 3401 2 AOI22X2 $T=247020 626520 0 0 $X=246840 $Y=626255
X16396 VSS: 2 VSS: 3417 3418 3349 3415 3416 2 NAND4X2_HS $T=279220 13800 0 180 $X=273520 $Y=9355
X16401 VSS: 2 VSS: 3416 3419 2 CLKBUFX2_HS $T=272320 13800 0 0 $X=272140 $Y=13535
X16405 VSS: 2 VSS: 3419 3364 3357 3354 3420 2 AOI22X2_HS $T=270480 22080 1 0 $X=270300 $Y=17635
X16433 VSS: 2 VSS: 2617 3421 3423 2 NAND2X2_HS $T=269560 46920 1 180 $X=266160 $Y=46655
X16437 VSS: 2 VSS: 3423 3417 3422 2 NOR2X2_HS $T=274620 46920 0 0 $X=274440 $Y=46655
X16446 VSS: 2 VSS: 3425 3424 3378 126 3414 2 AOI22X2_HS $T=275540 55200 1 180 $X=269840 $Y=54935
X16451 VSS: 2 VSS: 3422 3477 3427 3426 3425 2 NAND4X2_HS $T=280140 63480 0 180 $X=274440 $Y=59035
X16462 VSS: 2 VSS: 3428 3424 3381 3380 3414 2 AOI22X2_HS $T=275080 71760 1 0 $X=274900 $Y=67315
X16473 VSS: 2 VSS: 3239 3429 3431 3430 3428 2 NAND4X2_HS $T=271400 80040 1 0 $X=271220 $Y=75595
X16479 VSS: 2 VSS: 3429 3440 3433 3435 3434 2 AOI22X2 $T=280600 80040 1 180 $X=275820 $Y=79775
X16483 VSS: 2 VSS: 3244 3432 3433 3435 925 2 AOI22X2 $T=278300 88320 0 180 $X=273520 $Y=83875
X16488 VSS: 2 VSS: 3436 3424 3383 3382 3414 2 AOI22X2_HS $T=278760 88320 1 180 $X=273060 $Y=88055
X16492 VSS: 2 VSS: 3430 3438 3248 3246 3437 2 AOI22X2 $T=274620 96600 0 180 $X=269840 $Y=92155
X16499 VSS: 2 VSS: 3442 3434 3439 3441 3440 2 AOI22X1_HS $T=274160 96600 0 0 $X=273980 $Y=96335
X16505 VSS: 2 VSS: 3427 3438 3384 3249 3437 2 AOI22X2_HS $T=275540 104880 0 180 $X=269840 $Y=100435
X16512 VSS: 2 VSS: 3250 3432 3441 3439 925 2 AOI22X2 $T=275540 104880 0 0 $X=275360 $Y=104615
X16515 VSS: 2 VSS: 3443 3442 3444 3445 3436 2 NAND4X2_HS $T=277380 113160 0 180 $X=271680 $Y=108715
X16522 VSS: 2 VSS: 3444 3438 3256 3255 3437 2 AOI22X2_HS $T=272780 121440 0 180 $X=267080 $Y=116995
X16529 VSS: 2 VSS: 3446 3394 3350 2 NAND2X1 $T=276460 121440 0 0 $X=276280 $Y=121175
X16538 VSS: 2 VSS: 3448 3447 3443 2 NOR2X2_HS $T=272320 129720 0 0 $X=272140 $Y=129455
X16548 VSS: 2 VSS: 3450 3449 3448 2 NAND2X1_HS $T=272320 138000 1 180 $X=269840 $Y=137735
X16553 VSS: 2 VSS: 2438 3450 2 BUFX8_HS $T=267720 146280 1 0 $X=267540 $Y=141835
X16564 VSS: 2 VSS: 3328 3409 2971 3182 3490 2 AOI22X2_HS $T=275540 502320 0 0 $X=275360 $Y=502055
X16568 VSS: 2 VSS: 1985 3454 2 BUFX4_HS $T=267720 510600 1 0 $X=267540 $Y=506155
X16576 VSS: 2 VSS: 3454 3409 3184 3185 3400 2 AOI22X2_HS $T=270020 518880 0 180 $X=264320 $Y=514435
X16588 VSS: 2 VSS: 3208 3313 2 INVX4_HS $T=266340 527160 1 0 $X=266160 $Y=522715
X16595 VSS: 2 VSS: 1426 3496 2 BUFX16_HS $T=281980 527160 1 180 $X=271680 $Y=526895
X16598 VSS: 2 VSS: 2977 7589 1893 3455 2 DFFX1_HS $T=264500 535440 1 0 $X=264320 $Y=530995
X16602 VSS: 2 VSS: 2983 7590 2018 3455 2 DFFX1_HS $T=264040 535440 0 0 $X=263860 $Y=535175
X16613 VSS: 2 VSS: 2998 7591 2015 3455 2 DFFX1_HS $T=262660 552000 1 0 $X=262480 $Y=547555
X16618 VSS: 2 VSS: 3003 7592 1561 3455 2 DFFX1_HS $T=264040 552000 0 0 $X=263860 $Y=551735
X16627 VSS: 2 VSS: 3209 7593 1914 3455 2 DFFX1_HS $T=268640 560280 0 0 $X=268460 $Y=560015
X16637 VSS: 2 VSS: 2580 7594 2015 3457 2 DFFX1_HS $T=276460 568560 0 0 $X=276280 $Y=568295
X16639 VSS: 2 VSS: 1171 3458 2 BUFX8 $T=269560 576840 0 180 $X=264320 $Y=572395
X16642 VSS: 2 VSS: 2781 7595 2018 3457 2 DFFX1_HS $T=271860 576840 1 0 $X=271680 $Y=572395
X16646 VSS: 2 VSS: 2804 7596 1561 3457 2 DFFX1_HS $T=269100 576840 0 0 $X=268920 $Y=576575
X16652 VSS: 2 VSS: 2585 7597 1914 3457 2 DFFX1_HS $T=270020 585120 1 0 $X=269840 $Y=580675
X16656 VSS: 2 VSS: 2554 7598 2018 3459 2 DFFX1_HS $T=274160 585120 0 0 $X=273980 $Y=584855
X16657 VSS: 2 VSS: 2563 7599 1893 3459 2 DFFX1_HS $T=262660 593400 1 0 $X=262480 $Y=588955
X16665 VSS: 2 VSS: 2803 7600 2015 3459 2 DFFX1_HS $T=263580 601680 1 0 $X=263400 $Y=597235
X16675 VSS: 2 VSS: 2807 7601 1914 3459 2 DFFX1_HS $T=266800 609960 1 0 $X=266620 $Y=605515
X16678 VSS: 2 VSS: 2805 7602 1561 3459 2 DFFX1_HS $T=277380 609960 1 0 $X=277200 $Y=605515
X16680 VSS: 2 VSS: 2341 2598 3028 3029 3412 2 AOI22X1 $T=266800 609960 0 0 $X=266620 $Y=609695
X16686 VSS: 2 VSS: 2340 3460 3022 3205 3343 2 AOI22X1 $T=267720 618240 1 0 $X=267540 $Y=613795
X16696 VSS: 2 VSS: 2598 7603 1561 3499 2 DFFX1_HS $T=277380 618240 0 0 $X=277200 $Y=617975
X16699 VSS: 2 VSS: 2337 2601 3028 3029 3413 2 AOI22X1 $T=269560 626520 1 0 $X=269380 $Y=622075
X16710 VSS: 2 VSS: 1483 3460 3181 2 NAND2X4_HS $T=274160 634800 0 180 $X=268920 $Y=630355
X16717 VSS: 2 VSS: 3345 3409 3018 3460 3490 2 AOI22X2_HS $T=275540 634800 0 0 $X=275360 $Y=634535
X16735 VSS: 2 VSS: 3418 3461 3463 3464 3462 2 AOI22X2 $T=291180 13800 0 0 $X=291000 $Y=13535
X16748 VSS: 2 VSS: 3351 3466 3465 3463 3464 2 AOI22X2_HS $T=294860 22080 1 180 $X=289160 $Y=21815
X16752 VSS: 2 VSS: 3361 3466 3465 3468 3467 2 AOI22X2 $T=288420 30360 0 180 $X=283640 $Y=25915
X16760 VSS: 2 VSS: 3366 3462 3467 3468 3461 2 AOI22X1 $T=286120 30360 1 180 $X=283180 $Y=30095
X16766 VSS: 2 VSS: 3469 3468 3230 3225 3381 2 AOI22X1 $T=282900 38640 1 0 $X=282720 $Y=34195
X16778 VSS: 2 VSS: 3421 3470 3471 2 NOR2X4_HS $T=289340 38640 0 0 $X=289160 $Y=38375
X16785 VSS: 2 VSS: 3472 3461 2 BUFX2_HS $T=292560 46920 0 180 $X=289620 $Y=42475
X16795 VSS: 2 VSS: 3386 3474 3473 3465 3466 2 AOI22X1_HS $T=293480 46920 1 180 $X=290080 $Y=46655
X16801 VSS: 2 VSS: 3475 3472 3473 3474 3462 2 AOI22X2_HS $T=288880 55200 1 0 $X=288700 $Y=50755
X16810 VSS: 2 VSS: 3434 3476 2 CLKBUFX2 $T=293020 55200 1 180 $X=290540 $Y=54935
X16821 VSS: 2 VSS: 3477 3440 3478 3479 3434 2 AOI22X2 $T=285660 63480 1 180 $X=280880 $Y=63215
X16832 VSS: 2 VSS: 3377 3432 3478 3479 925 2 AOI22X2_HS $T=284280 71760 1 180 $X=278580 $Y=71495
X16837 VSS: 2 VSS: 3378 7604 134 3480 2 DFFX1_HS $T=294400 71760 0 0 $X=294220 $Y=71495
X16843 VSS: 2 VSS: 3383 7605 1885 3480 2 DFFX1_HS $T=294400 80040 1 0 $X=294220 $Y=75595
X16851 VSS: 2 VSS: 3381 7606 2871 3480 2 DFFX1_HS $T=293480 80040 0 0 $X=293300 $Y=79775
X16876 VSS: 2 VSS: 2785 2837 2 CLKBUFX4 $T=293940 96600 0 0 $X=293760 $Y=96335
X16881 VSS: 2 VSS: 3480 3519 2 CLKBUFX2 $T=296240 104880 0 180 $X=293760 $Y=100435
X16897 VSS: 2 VSS: 3482 3478 2312 2311 3249 2 AOI22X1 $T=280600 113160 0 0 $X=280420 $Y=112895
X16901 VSS: 2 VSS: 3481 3433 2312 2311 3246 2 AOI22X1 $T=292560 113160 0 0 $X=292380 $Y=112895
X16906 VSS: 2 VSS: 3523 3441 2312 2311 3255 2 AOI22X1 $T=294860 121440 1 0 $X=294680 $Y=116995
X16912 VSS: 2 VSS: 3484 3482 3483 2 NAND2X1 $T=286120 121440 0 0 $X=285940 $Y=121175
X16917 VSS: 2 VSS: 3526 3481 3488 2 NAND2X1 $T=294860 121440 0 0 $X=294680 $Y=121175
X16919 VSS: 2 VSS: 3447 3485 3446 3475 3391 2 NAND4X2_HS $T=287040 129720 0 180 $X=281340 $Y=125275
X16933 VSS: 2 VSS: 3449 3486 3528 2 NOR2X2_HS $T=293480 129720 0 0 $X=293300 $Y=129455
X16945 VSS: 2 VSS: 3487 2960 1949 410 3262 2 AOI22X1 $T=288420 138000 0 0 $X=288240 $Y=137735
X16951 VSS: 2 VSS: 3483 3169 1949 1525 3064 2 AOI22X1 $T=288420 146280 0 180 $X=285480 $Y=141835
X16958 VSS: 2 VSS: 3488 3166 1949 1525 3066 2 AOI22X1 $T=279220 146280 0 0 $X=279040 $Y=146015
X17040 VSS: 2 VSS: 3492 3493 3295 2 NAND2X1 $T=289800 510600 0 180 $X=287780 $Y=506155
X17051 VSS: 2 VSS: 1425 3534 2 BUFX8 $T=297160 510600 1 180 $X=291920 $Y=510335
X17059 VSS: 2 VSS: 3494 3208 2 CLKINVX2 $T=278760 518880 0 0 $X=278580 $Y=518615
X17064 VSS: 2 VSS: 935 3491 2 BUFX8_HS $T=294400 518880 1 180 $X=288700 $Y=518615
X17069 VSS: 2 VSS: 2976 7607 1893 3495 2 DFFX1_HS $T=283820 527160 1 0 $X=283640 $Y=522715
X17079 VSS: 2 VSS: 2989 7608 1893 3538 2 DFFX1_HS $T=294860 527160 0 0 $X=294680 $Y=526895
X17083 VSS: 2 VSS: 2982 7609 2018 3495 2 DFFX1_HS $T=284280 535440 1 0 $X=284100 $Y=530995
X17094 VSS: 2 VSS: 703 3424 2 BUFX8_HS $T=281520 543720 1 0 $X=281340 $Y=539275
X17103 VSS: 2 VSS: 3210 7610 2015 3495 2 DFFX1_HS $T=283360 543720 0 0 $X=283180 $Y=543455
X17107 VSS: 2 VSS: 1167 3497 2 BUFX8 $T=286580 552000 0 180 $X=281340 $Y=547555
X17110 VSS: 2 VSS: 947 3540 2 BUFX8 $T=297160 552000 0 180 $X=291920 $Y=547555
X17117 VSS: 2 VSS: 940 3541 2 BUFX16_HS $T=296700 552000 1 180 $X=286400 $Y=551735
X17121 VSS: 2 VSS: 3216 7611 1561 3495 2 DFFX1_HS $T=285200 560280 1 0 $X=285020 $Y=555835
X17133 VSS: 2 VSS: 3214 7612 1914 3495 2 DFFX1_HS $T=283360 568560 1 0 $X=283180 $Y=564115
X17145 VSS: 2 VSS: 2565 7613 1893 3457 2 DFFX1_HS $T=287040 576840 1 0 $X=286860 $Y=572395
X17151 VSS: 2 VSS: 3402 7614 1893 3498 2 DFFX1_HS $T=286580 576840 0 0 $X=286400 $Y=576575
X17155 VSS: 2 VSS: 3199 7615 2018 3498 2 DFFX1_HS $T=287040 585120 1 0 $X=286860 $Y=580675
X17166 VSS: 2 VSS: 2540 7616 1893 3499 2 DFFX1_HS $T=282440 593400 1 0 $X=282260 $Y=588955
X17171 VSS: 2 VSS: 2543 7617 2018 3499 2 DFFX1_HS $T=280140 593400 0 0 $X=279960 $Y=593135
X17176 VSS: 2 VSS: 3012 7618 2015 3499 2 DFFX1_HS $T=284740 601680 1 0 $X=284560 $Y=597235
X17184 VSS: 2 VSS: 3404 7619 2015 3498 2 DFFX1_HS $T=284740 601680 0 0 $X=284560 $Y=601415
X17195 VSS: 2 VSS: 3412 7620 1561 3498 2 DFFX1_HS $T=285200 609960 0 0 $X=285020 $Y=609695
X17204 VSS: 2 VSS: 3413 7621 1914 3498 2 DFFX1_HS $T=286580 618240 0 0 $X=286400 $Y=617975
X17214 VSS: 2 VSS: 2601 7622 1914 3499 2 DFFX1_HS $T=279680 626520 0 0 $X=279500 $Y=626255
X17230 VSS: 2 VSS: 972 3409 3222 3346 3490 2 AOI22X2_HS $T=281520 643080 1 0 $X=281340 $Y=638635
X17253 VSS: 2 VSS: 3420 3502 2 BUFX8_HS $T=307740 22080 0 180 $X=302040 $Y=17635
X17268 VSS: 2 VSS: 3503 3463 3230 3225 3378 2 AOI22X1 $T=309120 30360 1 0 $X=308940 $Y=25915
X17271 VSS: 2 VSS: 3464 7623 134 3504 2 DFFX1_HS $T=298540 30360 0 0 $X=298360 $Y=30095
X17273 VSS: 2 VSS: 3474 7624 1885 3504 2 DFFX1_HS $T=311420 30360 0 0 $X=311240 $Y=30095
X17282 VSS: 2 VSS: 3362 3500 3506 3507 3505 2 AOI22X1 $T=311880 38640 0 180 $X=308940 $Y=34195
X17287 VSS: 2 VSS: 3367 3508 3506 3507 3501 2 AOI22X1 $T=310960 38640 1 180 $X=308020 $Y=38375
X17311 VSS: 2 VSS: 3510 3509 2825 3031 3474 2 AOI22X1 $T=307740 55200 0 0 $X=307560 $Y=54935
X17319 VSS: 2 VSS: 3511 3231 3034 3040 3435 2 AOI22X1 $T=303600 63480 0 180 $X=300660 $Y=59035
X17329 VSS: 2 VSS: 3561 3394 3034 3040 3439 2 AOI22X1 $T=313720 63480 1 180 $X=310780 $Y=63215
X17336 VSS: 2 VSS: 3376 3515 3512 3514 3513 2 AOI22X2_HS $T=311880 71760 0 180 $X=306180 $Y=67315
X17340 VSS: 2 VSS: 3479 7625 134 3516 2 DFFX1_HS $T=308660 71760 0 0 $X=308480 $Y=71495
X17346 VSS: 2 VSS: 3435 7626 2871 3516 2 DFFX1_HS $T=308200 80040 1 0 $X=308020 $Y=75595
X17350 VSS: 2 VSS: 3439 7627 1885 3516 2 DFFX1_HS $T=308660 80040 0 0 $X=308480 $Y=79775
X17359 VSS: 2 VSS: 3242 3515 3517 3563 3513 2 AOI22X2_HS $T=312800 88320 0 180 $X=307100 $Y=83875
X17364 VSS: 2 VSS: 3431 3312 3563 3517 3518 2 AOI22X2_HS $T=310040 88320 0 0 $X=309860 $Y=88055
X17372 VSS: 2 VSS: 3426 3312 3514 3512 3518 2 AOI22X2_HS $T=306360 96600 1 0 $X=306180 $Y=92155
X17378 VSS: 2 VSS: 3553 7628 134 3385 2 DFFX1_HS $T=305440 96600 0 0 $X=305260 $Y=96335
X17382 VSS: 2 VSS: 3509 7629 1885 3385 2 DFFX1_HS $T=296240 104880 1 0 $X=296060 $Y=100435
X17385 VSS: 2 VSS: 3564 7630 2871 3385 2 DFFX1_HS $T=310960 104880 1 0 $X=310780 $Y=100435
X17389 VSS: 2 VSS: 3253 3513 3515 3521 3520 2 AOI22X2 $T=311420 104880 1 180 $X=306640 $Y=104615
X17398 VSS: 2 VSS: 3445 3312 3520 3521 3518 2 AOI22X2 $T=313260 113160 0 180 $X=308480 $Y=108715
X17403 VSS: 2 VSS: 3478 7631 134 3522 2 DFFX1_HS $T=308200 113160 0 0 $X=308020 $Y=112895
X17411 VSS: 2 VSS: 3441 7632 1885 3522 2 DFFX1_HS $T=309580 121440 1 0 $X=309400 $Y=116995
X17416 VSS: 2 VSS: 3524 3523 3525 2 NAND2X1 $T=305440 121440 0 0 $X=305260 $Y=121175
X17426 VSS: 2 VSS: 3485 3508 3566 3527 3501 2 AOI22X1_HS $T=312800 129720 0 180 $X=309400 $Y=125275
X17440 VSS: 2 VSS: 3393 3505 3527 3566 3500 2 AOI22X2 $T=313260 138000 0 180 $X=308480 $Y=133555
X17454 VSS: 2 VSS: 3525 3296 1949 1525 2889 2 AOI22X1 $T=304520 146280 1 0 $X=304340 $Y=141835
X17459 VSS: 2 VSS: 3529 410 wdata_i[5] 2 CLKAND2X2 $T=299000 146280 0 0 $X=298820 $Y=146015
X17541 VSS: 2 VSS: 2994 3531 2 INVX4_HS $T=310960 502320 1 180 $X=307560 $Y=502055
X17548 VSS: 2 VSS: 3493 3533 2312 2311 3532 2 AOI22X1 $T=304060 510600 0 180 $X=301120 $Y=506155
X17555 VSS: 2 VSS: 928 3572 2 BUFX16_HS $T=315560 510600 1 180 $X=305260 $Y=510335
X17562 VSS: 2 VSS: 3536 3532 3535 918 919 2 AOI22X2_HS $T=304060 518880 1 0 $X=303880 $Y=514435
X17568 VSS: 2 VSS: 2265 3537 3530 2 NAND2X4_HS $T=311880 518880 1 180 $X=306640 $Y=518615
X17575 VSS: 2 VSS: 3189 7633 2018 3538 2 DFFX1_HS $T=302680 527160 1 0 $X=302500 $Y=522715
X17588 VSS: 2 VSS: 3574 3546 2785 2796 3576 2 AOI22X1 $T=311420 535440 1 0 $X=311240 $Y=530995
X17591 VSS: 2 VSS: 3197 7634 2018 3539 2 DFFX1_HS $T=300840 535440 0 0 $X=300660 $Y=535175
X17599 VSS: 2 VSS: 3206 7635 1893 3539 2 DFFX1_HS $T=300840 543720 1 0 $X=300660 $Y=539275
X17605 VSS: 2 VSS: 3405 7636 2015 3539 2 DFFX1_HS $T=308200 543720 0 0 $X=308020 $Y=543455
X17611 VSS: 2 VSS: 3335 7637 1561 3539 2 DFFX1_HS $T=302680 552000 1 0 $X=302500 $Y=547555
X17616 VSS: 2 VSS: 3338 7638 1914 3539 2 DFFX1_HS $T=308660 552000 0 0 $X=308480 $Y=551735
X17625 VSS: 2 VSS: 3336 7639 2015 3538 2 DFFX1_HS $T=295780 560280 0 0 $X=295600 $Y=560015
X17640 VSS: 2 VSS: 3543 3542 3545 3544 2 NAND3X2_HS $T=310960 568560 1 180 $X=306180 $Y=568295
X17653 VSS: 2 VSS: 2542 7640 2018 3547 2 DFFX1_HS $T=300380 576840 0 0 $X=300200 $Y=576575
X17662 VSS: 2 VSS: 3579 3195 3546 3581 3196 2 AOI22X1 $T=310960 585120 1 0 $X=310780 $Y=580675
X17665 VSS: 2 VSS: 3011 7641 2015 3547 2 DFFX1_HS $T=300380 585120 0 0 $X=300200 $Y=584855
X17671 VSS: 2 VSS: 2971 7642 2018 3548 2 DFFX1_HS $T=297160 593400 1 0 $X=296980 $Y=588955
X17674 VSS: 2 VSS: 3185 7643 1893 3549 2 DFFX1_HS $T=310500 593400 1 0 $X=310320 $Y=588955
X17677 VSS: 2 VSS: 3184 7644 1893 3548 2 DFFX1_HS $T=298080 593400 0 0 $X=297900 $Y=593135
X17681 VSS: 2 VSS: 3182 7645 2018 3549 2 DFFX1_HS $T=310500 593400 0 0 $X=310320 $Y=593135
X17689 VSS: 2 VSS: 3217 7646 2015 3548 2 DFFX1_HS $T=309580 601680 1 0 $X=309400 $Y=597235
X17693 VSS: 2 VSS: 3408 7647 2015 3549 2 DFFX1_HS $T=306820 601680 0 0 $X=306640 $Y=601415
X17697 VSS: 2 VSS: 3343 7648 1561 3538 2 DFFX1_HS $T=297620 609960 1 0 $X=297440 $Y=605515
X17703 VSS: 2 VSS: 3219 7649 1914 3538 2 DFFX1_HS $T=309120 609960 0 0 $X=308940 $Y=609695
X17711 VSS: 2 VSS: 3346 7650 1914 3549 2 DFFX1_HS $T=309120 618240 1 0 $X=308940 $Y=613795
X17717 VSS: 2 VSS: 3460 7651 1561 3549 2 DFFX1_HS $T=305900 618240 0 0 $X=305720 $Y=617975
X17728 VSS: 2 VSS: 3018 7652 1561 3548 2 DFFX1_HS $T=301300 626520 0 0 $X=301120 $Y=626255
X17738 VSS: 2 VSS: 3222 7653 1914 3548 2 DFFX1_HS $T=310040 634800 1 0 $X=309860 $Y=630355
X17744 VSS: 2 VSS: 2602 7654 1914 3547 2 DFFX1_HS $T=309580 634800 0 0 $X=309400 $Y=634535
X17758 VSS: 2 VSS: 3347 3505 3550 3551 3500 2 AOI22X2_HS $T=313720 13800 1 0 $X=313540 $Y=9355
X17767 VSS: 2 VSS: 3415 3508 3551 3550 3501 2 AOI22X1_HS $T=316020 13800 0 0 $X=315840 $Y=13535
X17772 VSS: 2 VSS: 3463 7655 134 3552 2 DFFX1_HS $T=318780 22080 1 0 $X=318600 $Y=17635
X17777 VSS: 2 VSS: 3473 7656 1885 3552 2 DFFX1_HS $T=316940 22080 0 0 $X=316760 $Y=21815
X17784 VSS: 2 VSS: 3468 7657 2871 3552 2 DFFX1_HS $T=322460 30360 1 0 $X=322280 $Y=25915
X17790 VSS: 2 VSS: 3467 7658 2871 3504 2 DFFX1_HS $T=322000 30360 0 0 $X=321820 $Y=30095
X17804 VSS: 2 VSS: 3554 3553 2825 3031 3464 2 AOI22X1 $T=314640 46920 1 0 $X=314460 $Y=42475
X17812 VSS: 2 VSS: 3555 3473 3230 3225 3383 2 AOI22X1 $T=311880 46920 0 0 $X=311700 $Y=46655
X17830 VSS: 2 VSS: 3556 3558 3557 3559 3511 2 NAND4X1 $T=324300 55200 0 0 $X=324120 $Y=54935
X17834 VSS: 2 VSS: 3560 3224 3034 3040 3479 2 AOI22X1 $T=319240 63480 1 0 $X=319060 $Y=59035
X17854 VSS: 2 VSS: 3224 7659 134 3562 2 DFFX1_HS $T=320620 71760 0 0 $X=320440 $Y=71495
X17857 VSS: 2 VSS: 3231 7660 2871 3562 2 DFFX1_HS $T=321540 80040 1 0 $X=321360 $Y=75595
X17862 VSS: 2 VSS: 3394 7661 1885 3562 2 DFFX1_HS $T=321540 80040 0 0 $X=321360 $Y=79775
X17909 VSS: 2 VSS: 3249 7662 134 3565 2 DFFX1_HS $T=325220 113160 0 0 $X=325040 $Y=112895
X17914 VSS: 2 VSS: 3246 7663 2871 3565 2 DFFX1_HS $T=325680 121440 1 0 $X=325500 $Y=116995
X17919 VSS: 2 VSS: 3433 7664 2871 3522 2 DFFX1_HS $T=313260 121440 0 0 $X=313080 $Y=121175
X17922 VSS: 2 VSS: 3255 7665 1885 3565 2 DFFX1_HS $T=326600 121440 0 0 $X=326420 $Y=121175
X17944 VSS: 2 VSS: 3462 3568 2 CLKINVX8 $T=316940 138000 1 180 $X=312620 $Y=137735
X17951 VSS: 2 VSS: 3569 wdata_i[0] 1641 1949 3261 2 AOI22X1 $T=325680 146280 1 0 $X=325500 $Y=141835
X17956 VSS: 2 VSS: 3571 3286 1949 1641 wdata_i[7] 2 AOI22X1 $T=314180 146280 0 0 $X=314000 $Y=146015
X17961 VSS: 2 VSS: 3618 3571 2 INVX2 $T=327060 146280 0 0 $X=326880 $Y=146015
X18035 VSS: 2 VSS: rdata_o[12] 2576 2 BUFX2 $T=322460 502320 0 0 $X=322280 $Y=502055
X18040 VSS: 2 VSS: 919 3620 2 BUFX16_HS $T=333040 510600 0 180 $X=322740 $Y=506155
X18060 VSS: 2 VSS: 3575 3625 3492 2568 2 AOI21X1 $T=329360 518880 1 180 $X=326880 $Y=518615
X18065 VSS: 2 VSS: 3627 926 3533 3626 925 2 AOI22X1_HS $T=326600 527160 1 0 $X=326420 $Y=522715
X18098 VSS: 2 VSS: 3577 3496 2 BUFX2_HS $T=319700 552000 1 0 $X=319520 $Y=547555
X18122 VSS: 2 VSS: 3537 3578 3543 2 NOR2X2_HS $T=317400 568560 0 180 $X=314000 $Y=564115
X18135 VSS: 2 VSS: 3545 2994 3546 3581 3580 2 AOI22X1 $T=312340 576840 1 0 $X=312160 $Y=572395
X18143 VSS: 2 VSS: 2539 7666 1893 3547 2 DFFX1_HS $T=313260 576840 0 0 $X=313080 $Y=576575
X18151 VSS: 2 VSS: 3581 7667 1553 3457 2 DFFX1_HS $T=327060 585120 1 0 $X=326880 $Y=580675
X18204 VSS: 2 VSS: 3648 7668 1553 2324 2 DFFX1_HS $T=325220 626520 1 0 $X=325040 $Y=622075
X18211 VSS: 2 VSS: 2597 7669 1561 3547 2 DFFX1_HS $T=320620 626520 0 0 $X=320440 $Y=626255
X18238 VSS: 2 VSS: 3586 3584 3583 3585 3503 2 NAND4X1 $T=342240 13800 1 180 $X=339300 $Y=13535
X18250 VSS: 2 VSS: 3583 3550 3183 2808 3357 2 AOI22X1 $T=337180 22080 0 0 $X=337000 $Y=21815
X18259 VSS: 2 VSS: 3590 3586 3589 3588 2 NOR3X1 $T=339940 30360 1 0 $X=339760 $Y=25915
X18272 VSS: 2 VSS: 3591 3507 3183 2808 3358 2 AOI22X1 $T=335340 38640 1 0 $X=335160 $Y=34195
X18275 VSS: 2 VSS: 3588 3592 3554 3593 3560 2 NAND4X1 $T=330740 38640 1 180 $X=327800 $Y=38375
X18288 VSS: 2 VSS: 3594 3527 2606 2808 3389 2 AOI22X1 $T=344540 46920 0 180 $X=341600 $Y=42475
X18290 VSS: 2 VSS: 3557 3564 2825 3031 3467 2 AOI22X1 $T=328900 46920 0 0 $X=328720 $Y=46655
X18298 VSS: 2 VSS: 3592 126 3037 3042 3595 2 AOI22X1 $T=327980 55200 1 0 $X=327800 $Y=50755
X18305 VSS: 2 VSS: 3558 3380 3037 3042 3596 2 AOI22X1 $T=338100 55200 0 0 $X=337920 $Y=54935
X18313 VSS: 2 VSS: 3596 7670 2871 3598 2 DFFX1_HS $T=331660 63480 1 0 $X=331480 $Y=59035
X18318 VSS: 2 VSS: 3600 3382 3037 3042 3599 2 AOI22X1 $T=337180 63480 1 180 $X=334240 $Y=63215
X18328 VSS: 2 VSS: 3602 3600 3510 3601 3561 2 NAND4X1 $T=339940 71760 1 0 $X=339760 $Y=67315
X18333 VSS: 2 VSS: 3599 7671 1885 3598 2 DFFX1_HS $T=333040 71760 0 0 $X=332860 $Y=71495
X18341 VSS: 2 VSS: 3380 7672 2871 136 2 DFFX1_HS $T=339020 80040 1 0 $X=338840 $Y=75595
X18345 VSS: 2 VSS: 3382 7673 1885 136 2 DFFX1_HS $T=335800 80040 0 0 $X=335620 $Y=79775
X18352 VSS: 2 VSS: 3603 3606 3597 3605 3604 2 NAND4X1_HS $T=340400 88320 1 0 $X=340220 $Y=83875
X18366 VSS: 2 VSS: 3611 3610 3590 3608 3609 2 NAND4X1 $T=343620 96600 0 180 $X=340680 $Y=92155
X18369 VSS: 2 VSS: 3605 3607 3046 3047 3248 2 AOI22X1 $T=327980 96600 0 0 $X=327800 $Y=96335
X18378 VSS: 2 VSS: 3609 3612 3484 2568 2 AOI21X1 $T=332580 104880 0 180 $X=330100 $Y=100435
X18384 VSS: 2 VSS: 2991 3046 2 CLKBUFX4 $T=328900 104880 0 0 $X=328720 $Y=104615
X18398 VSS: 2 VSS: 3604 2568 3526 3613 2 AOI21X1 $T=344540 113160 0 180 $X=342060 $Y=108715
X18415 VSS: 2 VSS: 2992 3047 2 CLKBUFX4 $T=330280 129720 1 0 $X=330100 $Y=125275
X18432 VSS: 2 VSS: 3614 410 wdata_i[0] 2 CLKAND2X2 $T=340400 138000 1 0 $X=340220 $Y=133555
X18438 VSS: 2 VSS: 3615 3487 2 BUFX2 $T=333960 138000 0 0 $X=333780 $Y=137735
X18451 VSS: 2 VSS: 2949 3617 2 CLKBUFX4 $T=333040 146280 1 180 $X=330100 $Y=146015
X18455 VSS: 2 VSS: 3452 2 TIEHI $T=342240 146280 1 180 $X=340680 $Y=146015
X18457 VSS: 2 VSS: 3617 1118 2 CLKBUFX4 $T=343160 146280 0 0 $X=342980 $Y=146015
X18537 VSS: 2 VSS: 3318 3621 2 BUFX4_HS $T=342700 502320 1 180 $X=338840 $Y=502055
X18548 VSS: 2 VSS: 3623 3622 2991 2992 3535 2 AOI22X1 $T=329820 510600 0 0 $X=329640 $Y=510335
X18560 VSS: 2 VSS: 3619 3574 3624 3623 3575 2 NAND4X1 $T=339940 518880 1 0 $X=339760 $Y=514435
X18576 VSS: 2 VSS: 3630 3628 3629 3627 3536 2 NAND4X2_HS $T=337640 527160 1 180 $X=331940 $Y=526895
X18585 VSS: 2 VSS: 3546 7674 1553 3207 2 DFFX1_HS $T=332120 535440 1 0 $X=331940 $Y=530995
X18587 VSS: 2 VSS: 3322 3631 3632 2 NAND2X2_HS $T=331660 535440 1 180 $X=328260 $Y=535175
X18598 VSS: 2 VSS: 3632 3633 3630 2 NOR2X2_HS $T=329820 543720 1 0 $X=329640 $Y=539275
X18606 VSS: 2 VSS: 3635 3625 3634 3577 3534 2 AOI22X1_HS $T=340860 543720 1 180 $X=337460 $Y=543455
X18613 VSS: 2 VSS: 3622 7675 1553 3455 2 DFFX1_HS $T=335340 552000 1 0 $X=335160 $Y=547555
X18615 VSS: 2 VSS: 3631 3636 3637 2 NOR2X2_HS $T=329820 552000 0 0 $X=329640 $Y=551735
X18626 VSS: 2 VSS: 3637 3635 3640 3639 3638 2 NAND4X1_HS $T=337640 560280 1 0 $X=337460 $Y=555835
X18630 VSS: 2 VSS: 3542 3642 3622 3643 3641 2 AOI22X2_HS $T=338560 560280 1 180 $X=332860 $Y=560015
X18640 VSS: 2 VSS: 3642 3644 2 BUFX2_HS $T=343160 568560 0 180 $X=340220 $Y=564115
X18645 VSS: 2 VSS: 3645 3327 3622 3643 3330 2 AOI22X2_HS $T=339940 568560 1 180 $X=334240 $Y=568295
X18653 VSS: 2 VSS: 3636 3647 3646 3579 3645 2 NAND4X2_HS $T=333960 576840 1 0 $X=333780 $Y=572395
X18661 VSS: 2 VSS: 3640 1154 3648 3649 3323 2 AOI22X1_HS $T=341780 576840 1 180 $X=338380 $Y=576575
X18671 VSS: 2 VSS: 3650 3581 2317 2343 3649 2 AOI22X1 $T=333040 585120 1 180 $X=330100 $Y=584855
X18680 VSS: 2 VSS: 3544 3651 3582 2 AND2X1_HS $T=332580 593400 0 180 $X=329640 $Y=588955
X18687 VSS: 2 VSS: 3647 3652 3653 3192 3190 2 AOI22X1 $T=335800 593400 1 180 $X=332860 $Y=593135
X18699 VSS: 2 VSS: 3653 7676 1553 3459 2 DFFX1_HS $T=331200 601680 0 0 $X=331020 $Y=601415
X18707 VSS: 2 VSS: 3582 3654 3652 3653 2988 2 AOI22X2_HS $T=336720 609960 0 180 $X=331020 $Y=605515
X18712 VSS: 2 VSS: 3652 7677 1553 3538 2 DFFX1_HS $T=331200 609960 0 0 $X=331020 $Y=609695
X18722 VSS: 2 VSS: 3655 3656 3022 3205 3652 2 AOI22X1 $T=339480 618240 1 0 $X=339300 $Y=613795
X18726 VSS: 2 VSS: 3656 7678 1553 3549 2 DFFX1_HS $T=328440 618240 0 0 $X=328260 $Y=617975
X18755 VSS: 2 VSS: 3657 7679 1553 3547 2 DFFX1_HS $T=330740 643080 1 0 $X=330560 $Y=638635
X18784 VSS: 2 VSS: 3585 3658 3038 2603 3659 2 AOI22X1 $T=348220 30360 1 180 $X=345280 $Y=30095
X18795 VSS: 2 VSS: 3662 3661 3591 3660 3469 2 NAND4X1 $T=351900 38640 1 180 $X=348960 $Y=38375
X18805 VSS: 2 VSS: 3665 3663 3594 3664 3555 2 NAND4X1 $T=349600 46920 1 180 $X=346660 $Y=46655
X18812 VSS: 2 VSS: 3597 3662 3666 3556 2 NOR3X1 $T=350520 55200 1 0 $X=350340 $Y=50755
X18817 VSS: 2 VSS: 3595 7680 134 3598 2 DFFX1_HS $T=348220 55200 0 0 $X=348040 $Y=54935
X18823 VSS: 2 VSS: 3664 3668 3038 2603 3667 2 AOI22X1 $T=356500 63480 1 0 $X=356320 $Y=59035
X18837 VSS: 2 VSS: 3671 3665 3670 3602 2 NOR3X1 $T=354200 71760 0 0 $X=354020 $Y=71495
X18856 VSS: 2 VSS: 3608 3672 3046 3047 3384 2 AOI22X1 $T=347760 88320 0 0 $X=347580 $Y=88055
X18868 VSS: 2 VSS: 3610 3673 2837 2796 3514 2 AOI22X1 $T=351440 96600 0 0 $X=351260 $Y=96335
X18873 VSS: 2 VSS: 3675 3674 2837 2796 3520 2 AOI22X1 $T=350060 104880 1 0 $X=349880 $Y=100435
X18885 VSS: 2 VSS: 3520 7681 1885 3676 2 DFFX1_HS $T=356960 113160 1 0 $X=356780 $Y=108715
X18888 VSS: 2 VSS: 3678 3677 3046 3047 3256 2 AOI22X1 $T=347760 113160 0 0 $X=347580 $Y=112895
X18894 VSS: 2 VSS: 3680 3675 3671 3678 3679 2 NAND4X1 $T=348220 121440 1 0 $X=348040 $Y=116995
X18900 VSS: 2 VSS: 3679 3681 3524 2568 2 AOI21X1 $T=350520 121440 1 180 $X=348040 $Y=121175
X18912 VSS: 2 VSS: 3528 3684 3669 3682 3683 2 NAND4X4_HS $T=351440 129720 0 0 $X=351260 $Y=129455
X18921 VSS: 2 VSS: 3748 3070 410 1949 3137 2 AOI22X2 $T=356500 138000 0 0 $X=356320 $Y=137735
X18928 VSS: 2 VSS: 3686 410 wdata_i[7] 2 CLKAND2X2 $T=350520 146280 0 0 $X=350340 $Y=146015
X18929 VSS: 2 VSS: 1118 3685 2 CLKBUFX8 $T=357880 146280 1 180 $X=352640 $Y=146015
X18933 VSS: 2 VSS: 3688 1149 2 CLKBUFX2_HS $T=350980 502320 0 0 $X=350800 $Y=502055
X18938 VSS: 2 VSS: 3530 3689 3690 2 NOR2X2_HS $T=351440 510600 1 0 $X=351260 $Y=506155
X18945 VSS: 2 VSS: 3690 3691 3754 3692 2 NAND3X2_HS $T=361560 510600 1 180 $X=356780 $Y=510335
X18954 VSS: 2 VSS: 3691 3494 3576 3693 3694 2 AOI22X2_HS $T=356500 518880 0 0 $X=356320 $Y=518615
X18958 VSS: 2 VSS: 3576 7682 1553 2322 2 DFFX1_HS $T=352360 527160 1 0 $X=352180 $Y=522715
X18969 VSS: 2 VSS: 3692 3758 3757 2 AND2X1_HS $T=362940 535440 0 180 $X=360000 $Y=530995
X18974 VSS: 2 VSS: 3629 704 3693 3576 3687 2 AOI22X2_HS $T=355120 535440 0 0 $X=354940 $Y=535175
X18979 VSS: 2 VSS: 3693 7683 1553 2017 2 DFFX1_HS $T=354660 543720 1 0 $X=354480 $Y=539275
X18988 VSS: 2 VSS: 3760 7684 1553 3539 2 DFFX1_HS $T=355580 552000 1 0 $X=355400 $Y=547555
X18990 VSS: 2 VSS: 3638 3695 3696 1413 1412 2 AOI22X1_HS $T=354660 552000 1 180 $X=351260 $Y=551735
X19002 VSS: 2 VSS: 3646 3453 3697 3760 3401 2 AOI22X1_HS $T=358800 560280 0 0 $X=358620 $Y=560015
X19011 VSS: 2 VSS: 3698 960 3649 3648 3765 2 AOI22X1 $T=362020 568560 1 180 $X=359080 $Y=568295
X19020 VSS: 2 VSS: 3649 7685 1553 2802 2 DFFX1_HS $T=356960 576840 0 0 $X=356780 $Y=576575
X19024 VSS: 2 VSS: 3639 1686 3706 3699 1687 2 AOI22X2_HS $T=356500 585120 1 0 $X=356320 $Y=580675
X19028 VSS: 2 VSS: 3624 3701 3700 3702 2 NOR3X1 $T=352820 585120 0 0 $X=352640 $Y=584855
X19033 VSS: 2 VSS: 3701 3650 3705 3704 3703 2 NAND4X1 $T=350060 593400 1 0 $X=349880 $Y=588955
X19039 VSS: 2 VSS: 3706 7686 1553 2323 2 DFFX1_HS $T=354200 593400 0 0 $X=354020 $Y=593135
X19043 VSS: 2 VSS: 3704 3653 2555 2564 3696 2 AOI22X1 $T=352360 601680 0 180 $X=349420 $Y=597235
X19050 VSS: 2 VSS: 3707 3706 2013 2012 3648 2 AOI22X1 $T=356960 601680 0 0 $X=356780 $Y=601415
X19061 VSS: 2 VSS: 3708 3709 3028 3029 3697 2 AOI22X1 $T=361100 609960 1 180 $X=358160 $Y=609695
X19070 VSS: 2 VSS: 3633 3711 3710 3712 3769 2 NAND4X2_HS $T=356500 618240 0 0 $X=356320 $Y=617975
X19076 VSS: 2 VSS: 2324 3713 2 CLKBUFX4 $T=358800 626520 0 180 $X=355860 $Y=622075
X19080 VSS: 2 VSS: 3711 2546 3657 3709 2544 2 AOI22X1_HS $T=349140 626520 0 0 $X=348960 $Y=626255
X19086 VSS: 2 VSS: 3705 3657 2606 2808 3714 2 AOI22X1 $T=351900 634800 0 180 $X=348960 $Y=630355
X19093 VSS: 2 VSS: 3712 3181 3714 3656 3017 2 AOI22X2_HS $T=347760 634800 0 0 $X=347580 $Y=634535
X19103 VSS: 2 VSS: 3369 3719 3718 3717 3716 2 NAND4X4_HS $T=368920 13800 1 0 $X=368740 $Y=9355
X19112 VSS: 2 VSS: 3716 3721 3722 3553 3720 2 AOI22X2_HS $T=375820 13800 1 180 $X=370120 $Y=13535
X19118 VSS: 2 VSS: 3719 3724 3659 3595 3715 2 AOI22X2_HS $T=370300 22080 0 180 $X=364600 $Y=17635
X19125 VSS: 2 VSS: 3727 3726 3553 3722 3725 2 AOI22X2_HS $T=369380 22080 1 180 $X=363680 $Y=21815
X19134 VSS: 2 VSS: 3731 3723 3730 3729 3728 2 AOI22X2_HS $T=371680 30360 0 180 $X=365980 $Y=25915
X19141 VSS: 2 VSS: 3733 3732 3731 2 CLKAND2X2 $T=368920 30360 1 180 $X=366440 $Y=30095
X19149 VSS: 2 VSS: 3470 3734 3727 3733 2 NAND3X4_HS $T=371220 38640 0 180 $X=364140 $Y=34195
X19157 VSS: 2 VSS: 3660 3735 3038 2603 3736 2 AOI22X1 $T=365700 38640 0 0 $X=365520 $Y=38375
X19176 VSS: 2 VSS: 3732 3737 3659 3595 3738 2 AOI22X1_HS $T=370760 46920 1 180 $X=367360 $Y=46655
X19206 VSS: 2 VSS: 3739 3737 3736 3596 3738 2 AOI22X2 $T=361560 63480 0 0 $X=361380 $Y=63215
X19216 VSS: 2 VSS: 3669 3738 3599 3667 3737 2 AOI22X1_HS $T=367540 71760 0 180 $X=364140 $Y=67315
X19233 VSS: 2 VSS: 3740 3715 3724 3667 3599 2 AOI22X2_HS $T=373520 80040 0 180 $X=367820 $Y=75595
X19245 VSS: 2 VSS: 3606 3742 2837 2796 3563 2 AOI22X1 $T=361100 88320 1 0 $X=360920 $Y=83875
X19257 VSS: 2 VSS: 3517 7687 2871 3743 2 DFFX1_HS $T=367540 88320 0 0 $X=367360 $Y=88055
X19262 VSS: 2 VSS: 3738 3458 2 BUFX4 $T=361100 96600 1 0 $X=360920 $Y=92155
X19267 VSS: 2 VSS: 3512 7688 134 3743 2 DFFX1_HS $T=375820 96600 1 0 $X=375640 $Y=92155
X19275 VSS: 2 VSS: 3521 7689 1885 3743 2 DFFX1_HS $T=368000 96600 0 0 $X=367820 $Y=96335
X19280 VSS: 2 VSS: 3514 7690 134 3676 2 DFFX1_HS $T=364780 104880 1 0 $X=364600 $Y=100435
X19289 VSS: 2 VSS: 3563 7691 2871 3676 2 DFFX1_HS $T=375360 104880 0 0 $X=375180 $Y=104615
X19301 VSS: 2 VSS: 3384 7692 134 3744 2 DFFX1_HS $T=365700 113160 0 0 $X=365520 $Y=112895
X19307 VSS: 2 VSS: 3248 7693 2871 3744 2 DFFX1_HS $T=365700 121440 1 0 $X=365520 $Y=116995
X19314 VSS: 2 VSS: 3256 7694 1885 3744 2 DFFX1_HS $T=365700 121440 0 0 $X=365520 $Y=121175
X19320 VSS: 2 VSS: 3682 3726 3509 3745 3725 2 AOI22X2_HS $T=366620 129720 0 180 $X=360920 $Y=125275
X19338 VSS: 2 VSS: 3684 3747 3681 3746 3741 2 AOI22X2 $T=376740 138000 0 180 $X=371960 $Y=133555
X19355 VSS: 2 VSS: 3750 wdata_i[25] 1641 1949 3396 2 AOI22X2_HS $T=378120 146280 0 180 $X=372420 $Y=141835
X19361 VSS: 2 VSS: 3751 3569 2 INVX4 $T=362940 146280 0 0 $X=362760 $Y=146015
X19511 VSS: 2 VSS: 3726 1690 2 BUFX8 $T=366160 502320 1 180 $X=360920 $Y=502055
X19520 VSS: 2 VSS: 3753 3752 2 BUFX4_HS $T=373060 510600 0 180 $X=369200 $Y=506155
X19536 VSS: 2 VSS: 3535 7695 1553 2571 2 DFFX1_HS $T=366620 518880 1 0 $X=366440 $Y=514435
X19549 VSS: 2 VSS: 3207 3755 2 CLKBUFX4 $T=364320 527160 0 180 $X=361380 $Y=522715
X19560 VSS: 2 VSS: 3757 3491 3533 3626 3756 2 AOI22X1 $T=370760 527160 1 180 $X=367820 $Y=526895
X19570 VSS: 2 VSS: 3626 7696 1553 2014 2 DFFX1_HS $T=375820 535440 1 0 $X=375640 $Y=530995
X19591 VSS: 2 VSS: 3759 3693 2006 2007 3634 2 AOI22X1 $T=361560 543720 0 0 $X=361380 $Y=543455
X19599 VSS: 2 VSS: 3539 3761 2 CLKBUFX2 $T=367080 552000 0 180 $X=364600 $Y=547555
X19601 VSS: 2 VSS: 3643 7697 1553 3495 2 DFFX1_HS $T=368000 552000 1 0 $X=367820 $Y=547555
X19615 VSS: 2 VSS: 3762 3737 3696 3695 3458 2 AOI22X1 $T=367080 560280 1 0 $X=366900 $Y=555835
X19633 VSS: 2 VSS: 3764 3643 3039 3198 3760 2 AOI22X1 $T=373520 568560 1 0 $X=373340 $Y=564115
X19649 VSS: 2 VSS: 3578 3698 3763 3762 3766 2 NAND4X2_HS $T=366160 576840 1 0 $X=365980 $Y=572395
X19681 VSS: 2 VSS: 3696 7698 1553 2578 2 DFFX1_HS $T=372600 593400 1 0 $X=372420 $Y=588955
X19702 VSS: 2 VSS: 3697 7699 1553 3498 2 DFFX1_HS $T=372600 601680 0 0 $X=372420 $Y=601415
X19706 VSS: 2 VSS: 3700 3707 3708 3759 3655 2 NAND4X1 $T=363400 609960 0 180 $X=360460 $Y=605515
X19727 VSS: 2 VSS: 3710 1982 3768 3767 1676 2 AOI22X2_HS $T=369380 618240 1 0 $X=369200 $Y=613795
X19744 VSS: 2 VSS: 3709 7700 1553 3499 2 DFFX1_HS $T=368920 626520 1 0 $X=368740 $Y=622075
X19759 VSS: 2 VSS: 3714 7701 1553 3548 2 DFFX1_HS $T=368000 634800 1 0 $X=367820 $Y=630355
X19807 VSS: 2 VSS: 3550 7702 134 3770 2 DFFX1_HS $T=380880 30360 0 0 $X=380700 $Y=30095
X19815 VSS: 2 VSS: 3507 7703 2871 3770 2 DFFX1_HS $T=380420 38640 0 0 $X=380240 $Y=38375
X19829 VSS: 2 VSS: 3771 3715 3724 3736 3596 2 AOI22X2_HS $T=384100 55200 0 180 $X=378400 $Y=50755
X19834 VSS: 2 VSS: 3527 7704 1885 3770 2 DFFX1_HS $T=378580 55200 0 0 $X=378400 $Y=54935
X19841 VSS: 2 VSS: 3236 3817 3802 3812 3771 2 NAND4X4_HS $T=392380 63480 1 0 $X=392200 $Y=59035
X19852 VSS: 2 VSS: 3818 3820 3739 2 AND2X2_HS $T=392380 71760 1 0 $X=392200 $Y=67315
X19856 VSS: 2 VSS: 3717 3772 3612 3773 3774 2 AOI22X2_HS $T=392380 71760 1 180 $X=386680 $Y=71495
X19864 VSS: 2 VSS: 3734 3747 3612 3773 3741 2 AOI22X2_HS $T=384100 80040 1 180 $X=378400 $Y=79775
X19877 VSS: 2 VSS: 3245 3775 3819 2 NOR2X4_HS $T=391920 88320 0 0 $X=391740 $Y=88055
X19886 VSS: 2 VSS: 3776 3521 3045 3238 3746 2 AOI22X1 $T=392380 96600 1 180 $X=389440 $Y=96335
X19910 VSS: 2 VSS: 3824 3720 3509 3745 3721 2 AOI22X1_HS $T=391460 121440 1 0 $X=391280 $Y=116995
X19935 VSS: 2 VSS: 3813 3568 2 INVX8_HS $T=397900 138000 1 180 $X=392660 $Y=137735
X19942 VSS: 2 VSS: 3777 3750 2 INVX4_HS $T=378580 146280 0 0 $X=378400 $Y=146015
X19948 VSS: 2 VSS: rdata_o[16] 2987 2 BUFX2 $T=378120 502320 0 0 $X=377940 $Y=502055
X19953 VSS: 2 VSS: rdata_o[23] 3000 2 BUFX2 $T=392380 502320 0 0 $X=392200 $Y=502055
X19956 VSS: 2 VSS: 3532 7705 1553 2321 2 DFFX1_HS $T=381800 510600 1 0 $X=381620 $Y=506155
X19958 VSS: 2 VSS: 3533 7706 1553 2005 2 DFFX1_HS $T=392840 510600 1 0 $X=392660 $Y=506155
X19961 VSS: 2 VSS: 3754 3753 3532 3535 3779 2 AOI22X1 $T=388240 510600 1 180 $X=385300 $Y=510335
X19970 VSS: 2 VSS: 3508 3833 2 BUFX16_HS $T=397900 518880 1 180 $X=387600 $Y=518615
X19972 VSS: 2 VSS: 3625 7707 1553 2570 2 DFFX1_HS $T=378120 527160 1 0 $X=377940 $Y=522715
X19990 VSS: 2 VSS: 3628 3688 3780 3781 912 2 AOI22X1_HS $T=389620 543720 0 180 $X=386220 $Y=539275
X19995 VSS: 2 VSS: 3758 3540 3781 3780 3424 2 AOI22X1 $T=386400 543720 0 0 $X=386220 $Y=543455
X20001 VSS: 2 VSS: 915 3782 2 BUFX16_HS $T=390540 552000 0 180 $X=380240 $Y=547555
X20003 VSS: 2 VSS: 3763 3783 3634 3625 3747 2 AOI22X1_HS $T=377660 552000 0 0 $X=377480 $Y=551735
X20015 VSS: 2 VSS: 3651 3784 3697 3760 3785 2 AOI22X1 $T=379960 560280 0 0 $X=379780 $Y=560015
X20027 VSS: 2 VSS: 3695 7708 1553 2577 2 DFFX1_HS $T=390080 568560 0 0 $X=389900 $Y=568295
X20035 VSS: 2 VSS: 3702 3786 3787 3764 3788 2 NAND4X1 $T=385020 576840 1 180 $X=382080 $Y=576575
X20041 VSS: 2 VSS: 3789 1690 2 BUFX2 $T=383180 585120 1 0 $X=383000 $Y=580675
X20049 VSS: 2 VSS: 3766 3790 3706 3699 3789 2 AOI22X2_HS $T=391460 585120 1 180 $X=385760 $Y=584855
X20057 VSS: 2 VSS: 3787 3699 1991 1990 3767 2 AOI22X1 $T=380880 593400 0 0 $X=380700 $Y=593135
X20063 VSS: 2 VSS: 3788 3791 1701 1726 3626 2 AOI22X1 $T=382260 601680 1 0 $X=382080 $Y=597235
X20075 VSS: 2 VSS: 3780 7709 1553 2579 2 DFFX1_HS $T=385020 609960 1 0 $X=384840 $Y=605515
X20077 VSS: 2 VSS: 3703 3768 2320 2558 3780 2 AOI22X1 $T=382720 609960 1 180 $X=379780 $Y=609695
X20089 VSS: 2 VSS: 3769 3791 1206 2 NAND2X2 $T=389160 618240 1 180 $X=386680 $Y=617975
X20097 VSS: 2 VSS: 3792 2595 3709 3657 2596 2 AOI22X1_HS $T=380420 626520 1 180 $X=377020 $Y=626255
X20110 VSS: 2 VSS: 3793 3490 3656 3714 3409 2 AOI22X1_HS $T=387320 634800 1 180 $X=383920 $Y=634535
X20115 VSS: 2 VSS: 3689 3794 3795 3793 3792 2 NAND4X2_HS $T=388700 643080 0 180 $X=383000 $Y=638635
X20135 VSS: 2 VSS: 3798 3728 3796 3797 3723 2 AOI22X2 $T=410320 22080 0 180 $X=405540 $Y=17635
X20141 VSS: 2 VSS: 3800 3722 3024 3226 3730 2 AOI22X1 $T=400660 22080 1 180 $X=397720 $Y=21815
X20150 VSS: 2 VSS: 3802 3801 3797 3796 3799 2 AOI22X2 $T=408940 30360 0 180 $X=404160 $Y=25915
X20160 VSS: 2 VSS: 3804 3803 3024 3226 3797 2 AOI22X1 $T=404340 30360 0 0 $X=404160 $Y=30095
X20164 VSS: 2 VSS: 3807 3745 3024 3226 3806 2 AOI22X1 $T=404340 38640 0 180 $X=401400 $Y=34195
X20173 VSS: 2 VSS: 3589 3800 3808 3809 3805 2 NAND4X1 $T=404800 38640 0 0 $X=404620 $Y=38375
X20175 VSS: 2 VSS: 3811 3810 3564 3803 3725 2 AOI22X2_HS $T=399280 46920 0 180 $X=393580 $Y=42475
X20185 VSS: 2 VSS: 3812 3721 3803 3564 3720 2 AOI22X2 $T=402500 46920 1 180 $X=397720 $Y=46655
X20199 VSS: 2 VSS: 3666 3804 3815 3816 3814 2 NAND4X1 $T=407100 55200 0 0 $X=406920 $Y=54935
X20207 VSS: 2 VSS: 3819 3798 3811 3818 2 NAND3X4_HS $T=403420 63480 1 180 $X=396340 $Y=63215
X20223 VSS: 2 VSS: 3809 3512 3045 3238 3773 2 AOI22X1 $T=399740 80040 1 0 $X=399560 $Y=75595
X20233 VSS: 2 VSS: 3820 3747 3613 3821 3741 2 AOI22X2_HS $T=399740 88320 0 180 $X=394040 $Y=83875
X20247 VSS: 2 VSS: 3816 3517 3045 3238 3821 2 AOI22X1 $T=400200 96600 1 0 $X=400020 $Y=92155
X20258 VSS: 2 VSS: 3817 3772 3774 3821 3613 2 AOI22X2 $T=399740 104880 0 180 $X=394960 $Y=100435
X20269 VSS: 2 VSS: 3822 3772 3681 3746 3774 2 AOI22X2 $T=395600 113160 1 0 $X=395420 $Y=108715
X20277 VSS: 2 VSS: 3825 3740 3824 3822 3823 2 NAND4X4_HS $T=395600 113160 0 0 $X=395420 $Y=112895
X20291 VSS: 2 VSS: 3823 3801 3799 3826 3806 2 AOI22X2_HS $T=408940 121440 1 180 $X=403240 $Y=121175
X20295 VSS: 2 VSS: 3683 3728 3826 3806 3723 2 AOI22X2 $T=404800 129720 0 180 $X=400020 $Y=125275
X20302 VSS: 2 VSS: 3259 3825 3827 2 NOR2X4_HS $T=396980 129720 0 0 $X=396800 $Y=129455
X20311 VSS: 2 VSS: 3364 3828 2 BUFX4_HS $T=409400 138000 0 180 $X=405540 $Y=133555
X20321 VSS: 2 VSS: 2806 3397 2 CLKBUFX8 $T=402040 146280 0 180 $X=396800 $Y=141835
X20325 VSS: 2 VSS: 3192 3852 2 BUFX8_HS $T=414000 146280 0 180 $X=408300 $Y=141835
X20329 VSS: 2 VSS: 3829 410 wdata_i[25] 2 CLKAND2X2 $T=396520 146280 0 0 $X=396340 $Y=146015
X20406 VSS: 2 VSS: 3490 3830 2 INVX4_HS $T=406180 502320 1 180 $X=402780 $Y=502055
X20417 VSS: 2 VSS: 2996 3832 2 BUFX2_HS $T=409400 510600 1 180 $X=406460 $Y=510335
X20421 VSS: 2 VSS: 3779 3572 2 BUFX4_HS $T=399740 518880 1 0 $X=399560 $Y=514435
X20433 VSS: 2 VSS: 2595 3833 2 BUFX16_HS $T=398820 527160 1 0 $X=398640 $Y=522715
X20440 VSS: 2 VSS: 3399 3834 2 BUFX16_HS $T=405720 527160 1 180 $X=395420 $Y=526895
X20453 VSS: 2 VSS: 3837 912 3835 3836 3688 2 AOI22X2_HS $T=405720 535440 1 180 $X=400020 $Y=535175
X20467 VSS: 2 VSS: 3568 3838 2 BUFX4_HS $T=410320 543720 1 180 $X=406460 $Y=543455
X20479 VSS: 2 VSS: 3634 7710 1553 2325 2 DFFX1_HS $T=398820 552000 0 0 $X=398640 $Y=551735
X20492 VSS: 2 VSS: 3781 7711 1553 2023 2 DFFX1_HS $T=400660 560280 0 0 $X=400480 $Y=560015
X20496 VSS: 2 VSS: 3786 3781 1695 1716 3695 2 AOI22X1 $T=397900 568560 1 0 $X=397720 $Y=564115
X20509 VSS: 2 VSS: 3699 7712 1553 2780 2 DFFX1_HS $T=398360 576840 1 0 $X=398180 $Y=572395
X20517 VSS: 2 VSS: 3860 7713 816 2780 2 DFFX1_HS $T=407100 576840 0 0 $X=406920 $Y=576575
X20519 VSS: 2 VSS: 2579 3839 2 CLKBUFX8 $T=400660 585120 0 180 $X=395420 $Y=580675
X20534 VSS: 2 VSS: 3863 3838 2 CLKBUFX2_HS $T=408480 593400 1 0 $X=408300 $Y=588955
X20539 VSS: 2 VSS: 3836 7714 816 2579 2 DFFX1_HS $T=398360 593400 0 0 $X=398180 $Y=593135
X20549 VSS: 2 VSS: 3767 7715 1553 2806 2 DFFX1_HS $T=397440 601680 0 0 $X=397260 $Y=601415
X20564 VSS: 2 VSS: 3864 7716 816 2806 2 DFFX1_HS $T=406640 609960 0 0 $X=406460 $Y=609695
X20569 VSS: 2 VSS: 3794 3840 3768 3767 3841 2 AOI22X1_HS $T=407100 618240 0 180 $X=403700 $Y=613795
X20577 VSS: 2 VSS: 3841 3842 2 CLKINVX2 $T=402960 618240 0 0 $X=402780 $Y=617975
X20583 VSS: 2 VSS: 3768 7717 1553 2799 2 DFFX1_HS $T=401580 626520 1 0 $X=401400 $Y=622075
X20589 VSS: 2 VSS: 3791 7718 1553 2800 2 DFFX1_HS $T=396520 626520 0 0 $X=396340 $Y=626255
X20603 VSS: 2 VSS: 3795 3791 3843 2 NAND2X1 $T=403420 634800 0 0 $X=403240 $Y=634535
X20622 VSS: 2 VSS: 3718 3799 3729 3730 3801 2 AOI22X2_HS $T=414000 13800 0 0 $X=413820 $Y=13535
X20649 VSS: 2 VSS: 3805 3354 3022 3205 3873 2 AOI22X1 $T=427340 30360 1 180 $X=424400 $Y=30095
X20658 VSS: 2 VSS: 3876 3871 3875 2 AND2X2_HS $T=425500 38640 1 0 $X=425320 $Y=34195
X20682 VSS: 2 VSS: 3814 3359 3022 3205 3844 2 AOI22X1 $T=415380 55200 0 180 $X=412440 $Y=50755
X20709 VSS: 2 VSS: 3815 3506 3028 3029 3845 2 AOI22X1 $T=417680 71760 0 180 $X=414740 $Y=67315
X20724 VSS: 2 VSS: 3593 3847 3039 3198 3846 2 AOI22X1 $T=420900 80040 0 180 $X=417960 $Y=75595
X20754 VSS: 2 VSS: 3670 3807 3848 3776 3849 2 NAND4X1 $T=411700 96600 0 0 $X=411520 $Y=96335
X20768 VSS: 2 VSS: 3849 3390 3022 3205 3850 2 AOI22X1 $T=414000 104880 1 180 $X=411060 $Y=104615
X20789 VSS: 2 VSS: 3848 3566 3028 3029 3851 2 AOI22X1 $T=416760 121440 0 180 $X=413820 $Y=116995
X20805 VSS: 2 VSS: 3897 3895 3893 2 NOR2X4_HS $T=431020 129720 0 180 $X=425780 $Y=125275
X20833 VSS: 2 VSS: 3853 1525 wdata_i[23] 2 CLKAND2X2 $T=413080 146280 0 0 $X=412900 $Y=146015
X20914 VSS: 2 VSS: 3502 3830 2 INVX4_HS $T=413080 502320 0 0 $X=412900 $Y=502055
X20922 VSS: 2 VSS: 3854 813 2846 2 NAND2X4_HS $T=414920 510600 1 0 $X=414740 $Y=506155
X20929 VSS: 2 VSS: 3904 3854 2 INVX16_HS $T=424580 510600 0 0 $X=424400 $Y=510335
X20938 VSS: 2 VSS: 3906 918 3905 3903 3620 2 AOI22X1_HS $T=425960 518880 1 0 $X=425780 $Y=514435
X20939 VSS: 2 VSS: 3694 3855 2 CLKBUFX2 $T=413080 518880 1 180 $X=410600 $Y=518615
X20960 VSS: 2 VSS: 3856 3424 3836 3835 3540 2 AOI22X2 $T=415380 535440 1 0 $X=415200 $Y=530995
X20976 VSS: 2 VSS: 3857 3906 3914 3837 3913 2 NAND4X2_HS $T=425500 543720 1 0 $X=425320 $Y=539275
X20989 VSS: 2 VSS: 3456 3916 3917 2 NAND2X2_HS $T=427800 552000 0 180 $X=424400 $Y=547555
X20995 VSS: 2 VSS: 3782 3918 2 CLKBUFX4 $T=427800 552000 1 180 $X=424860 $Y=551735
X21003 VSS: 2 VSS: 1117 3858 2 BUFX16_HS $T=427340 560280 0 180 $X=417040 $Y=555835
X21007 VSS: 2 VSS: 3835 7719 816 2023 2 DFFX1_HS $T=413080 560280 0 0 $X=412900 $Y=560015
X21039 VSS: 2 VSS: 3457 3862 2 CLKBUFX8 $T=424120 585120 0 180 $X=418880 $Y=580675
X21040 VSS: 2 VSS: 3861 1690 3860 3924 3790 2 AOI22X1 $T=424120 585120 1 0 $X=423940 $Y=580675
X21047 VSS: 2 VSS: 3919 7720 816 2577 2 DFFX1_HS $T=424120 585120 0 0 $X=423940 $Y=584855
X21065 VSS: 2 VSS: 1170 3859 2 BUFX8 $T=423200 601680 0 180 $X=417960 $Y=597235
X21094 VSS: 2 VSS: 3842 3863 2 CLKBUFX2 $T=418140 618240 0 0 $X=417960 $Y=617975
X21113 VSS: 2 VSS: 3865 3863 2 BUFX2_HS $T=411240 634800 1 0 $X=411060 $Y=630355
X21122 VSS: 2 VSS: 3935 3490 3866 3936 3409 2 AOI22X1 $T=424580 634800 0 0 $X=424400 $Y=634535
X21129 VSS: 2 VSS: 1989 3865 2 INVX8_HS $T=419060 643080 1 0 $X=418880 $Y=638635
X21136 VSS: 2 VSS: 3724 3867 2 BUFX8_HS $T=433320 13800 0 180 $X=427620 $Y=9355
X21148 VSS: 2 VSS: 3584 3868 3019 2343 3729 2 AOI22X1 $T=436540 22080 1 0 $X=436360 $Y=17635
X21151 VSS: 2 VSS: 3871 3870 3868 3673 3869 2 AOI22X2_HS $T=433780 22080 1 180 $X=428080 $Y=21815
X21158 VSS: 2 VSS: 3661 3872 3019 2343 3796 2 AOI22X1 $T=433320 30360 1 0 $X=433140 $Y=25915
X21166 VSS: 2 VSS: 3357 7721 134 3874 2 DFFX1_HS $T=440680 30360 0 0 $X=440500 $Y=30095
X21171 VSS: 2 VSS: 3358 7722 2871 3874 2 DFFX1_HS $T=440680 38640 1 0 $X=440500 $Y=34195
X21174 VSS: 2 VSS: 3471 3876 3877 2 NAND2X4_HS $T=434240 38640 0 0 $X=434060 $Y=38375
X21177 VSS: 2 VSS: 3808 3551 3028 3029 3878 2 AOI22X1 $T=432400 46920 0 180 $X=429460 $Y=42475
X21185 VSS: 2 VSS: 3663 3879 3019 2343 3826 2 AOI22X1 $T=439760 46920 1 180 $X=436820 $Y=46655
X21192 VSS: 2 VSS: 3881 3886 3673 3868 3880 2 AOI22X2_HS $T=444360 55200 0 180 $X=438660 $Y=50755
X21197 VSS: 2 VSS: 3389 7723 1885 3874 2 DFFX1_HS $T=440220 55200 0 0 $X=440040 $Y=54935
X21207 VSS: 2 VSS: 3882 3938 3883 3878 3846 2 AOI22X2_HS $T=446200 63480 1 180 $X=440500 $Y=63215
X21213 VSS: 2 VSS: 3559 3890 3039 3198 3939 2 AOI22X1 $T=443900 71760 0 180 $X=440960 $Y=67315
X21218 VSS: 2 VSS: 3237 3940 3941 3884 2 NAND3X4_HS $T=445740 71760 1 180 $X=438660 $Y=71495
X21223 VSS: 2 VSS: 3884 3880 3872 3742 3885 2 AOI22X2 $T=444360 80040 0 180 $X=439580 $Y=75595
X21229 VSS: 2 VSS: 3885 3886 2 CLKBUFX2 $T=442980 80040 1 180 $X=440500 $Y=79775
X21231 VSS: 2 VSS: 3887 3870 3872 3742 3869 2 AOI22X2 $T=437460 88320 0 180 $X=432680 $Y=83875
X21236 VSS: 2 VSS: 3775 3887 3888 3889 2 NAND3X4_HS $T=431940 88320 0 0 $X=431760 $Y=88055
X21240 VSS: 2 VSS: 3888 3180 3890 3607 3644 2 AOI22X1_HS $T=432400 96600 0 180 $X=429000 $Y=92155
X21246 VSS: 2 VSS: 3875 3180 3847 3672 3644 2 AOI22X1 $T=434700 96600 0 0 $X=434520 $Y=96335
X21250 VSS: 2 VSS: 3891 3870 3674 2 NAND2X2_HS $T=431020 104880 0 180 $X=427620 $Y=100435
X21258 VSS: 2 VSS: 3892 3879 3869 2 NAND2X2 $T=438840 104880 1 180 $X=436360 $Y=104615
X21262 VSS: 2 VSS: 3893 3891 3892 2 NAND2X2_HS $T=428260 113160 1 0 $X=428080 $Y=108715
X21274 VSS: 2 VSS: 3895 3894 2 INVX2_HS $T=432400 121440 0 180 $X=429920 $Y=116995
X21284 VSS: 2 VSS: 3613 7724 2871 3896 2 DFFX1_HS $T=441600 121440 0 0 $X=441420 $Y=121175
X21289 VSS: 2 VSS: 3681 7725 1885 3896 2 DFFX1_HS $T=440680 129720 1 0 $X=440500 $Y=125275
X21290 VSS: 2 VSS: 3486 3897 3898 2 NAND2X4_HS $T=427800 129720 0 0 $X=427620 $Y=129455
X21296 VSS: 2 VSS: 3899 3900 2 BUFX2 $T=429180 138000 1 0 $X=429000 $Y=133555
X21302 VSS: 2 VSS: 3900 3314 1949 1525 2879 2 AOI22X1 $T=426880 138000 0 0 $X=426700 $Y=137735
X21310 VSS: 2 VSS: 3901 2958 1949 410 3267 2 AOI22X1 $T=437000 146280 1 0 $X=436820 $Y=141835
X21313 VSS: 2 VSS: 1413 3867 2 CLKBUFX8_HS $T=436080 146280 1 180 $X=427160 $Y=146015
X21318 VSS: 2 VSS: 3869 3531 2 INVX8_HS $T=434700 502320 1 180 $X=429460 $Y=502055
X21335 VSS: 2 VSS: 3907 3779 3905 3903 2997 2 AOI22X1 $T=431020 518880 1 180 $X=428080 $Y=518615
X21342 VSS: 2 VSS: 3908 3856 3910 3909 3907 2 NAND4X1_HS $T=428720 527160 1 0 $X=428540 $Y=522715
X21348 VSS: 2 VSS: 3834 3911 2 BUFX2_HS $T=432860 527160 1 180 $X=429920 $Y=526895
X21361 VSS: 2 VSS: 3913 925 3954 3912 926 2 AOI22X2_HS $T=440680 535440 0 0 $X=440500 $Y=535175
X21366 VSS: 2 VSS: 3916 3908 3915 2 NOR2X1_HS $T=429180 543720 1 180 $X=426700 $Y=543455
X21390 VSS: 2 VSS: 3920 3835 1695 1716 3919 2 AOI22X1 $T=436540 560280 0 0 $X=436360 $Y=560015
X21393 VSS: 2 VSS: 3858 3922 3921 2 NAND2X2_HS $T=430100 568560 0 180 $X=426700 $Y=564115
X21398 VSS: 2 VSS: 3921 3857 3923 2 NOR2X2_HS $T=426880 568560 0 0 $X=426700 $Y=568295
X21426 VSS: 2 VSS: 3964 3927 3926 3928 3963 2 NAND4X2_HS $T=438840 593400 1 0 $X=438660 $Y=588955
X21427 VSS: 2 VSS: 3929 3860 1991 1990 3864 2 AOI22X1 $T=427800 593400 0 0 $X=427620 $Y=593135
X21440 VSS: 2 VSS: 3928 3925 3919 1412 1413 2 AOI22X2_HS $T=442060 601680 1 180 $X=436360 $Y=601415
X21445 VSS: 2 VSS: 3927 1686 3924 3860 1687 2 AOI22X2_HS $T=430560 609960 1 0 $X=430380 $Y=605515
X21456 VSS: 2 VSS: 3931 3840 3930 3864 1989 2 AOI22X2 $T=441600 618240 0 180 $X=436820 $Y=613795
X21462 VSS: 2 VSS: 3933 3932 3843 2 NAND2X1 $T=436540 618240 1 180 $X=434520 $Y=617975
X21471 VSS: 2 VSS: 3915 3934 3935 3933 3931 2 NAND4X2_HS $T=433320 626520 0 0 $X=433140 $Y=626255
X21477 VSS: 2 VSS: 3932 7726 816 2800 2 DFFX1_HS $T=437000 634800 1 0 $X=436820 $Y=630355
X21550 VSS: 2 VSS: 2317 3019 2 CLKBUFX4 $T=454480 46920 1 0 $X=454300 $Y=42475
X21578 VSS: 2 VSS: 3368 3882 3881 3937 2 NAND3X4_HS $T=443440 63480 1 0 $X=443260 $Y=59035
X21651 VSS: 2 VSS: 3746 7727 1885 3942 2 DFFX1_HS $T=455400 96600 0 0 $X=455220 $Y=96335
X21659 VSS: 2 VSS: 3821 7728 2871 3942 2 DFFX1_HS $T=455400 104880 1 0 $X=455220 $Y=100435
X21667 VSS: 2 VSS: 3773 7729 134 3942 2 DFFX1_HS $T=454940 104880 0 0 $X=454760 $Y=104615
X21679 VSS: 2 VSS: 3894 3180 3943 3677 3644 2 AOI22X1_HS $T=448500 113160 1 180 $X=445100 $Y=112895
X21689 VSS: 2 VSS: 3612 7730 134 3896 2 DFFX1_HS $T=446660 121440 1 0 $X=446480 $Y=116995
X21710 VSS: 2 VSS: 3944 2866 2 CLKBUFX2 $T=457240 129720 1 180 $X=454760 $Y=129455
X21715 VSS: 2 VSS: 3945 3901 2 BUFX2 $T=446200 138000 1 0 $X=446020 $Y=133555
X21726 VSS: 2 VSS: 3947 3944 1949 1641 wdata_i[20] 2 AOI22X1_HS $T=453560 138000 0 0 $X=453380 $Y=137735
X21734 VSS: 2 VSS: 3948 3947 2 INVX2 $T=454480 146280 1 0 $X=454300 $Y=141835
X21739 VSS: 2 VSS: 3902 2 TIELO $T=444820 146280 1 180 $X=443260 $Y=146015
X21744 VSS: 2 VSS: 3949 1525 wdata_i[20] 2 CLKAND2X2 $T=454480 146280 0 0 $X=454300 $Y=146015
X21879 VSS: 2 VSS: 3950 3912 2312 2311 3903 2 AOI22X1 $T=443900 510600 1 0 $X=443720 $Y=506155
X21890 VSS: 2 VSS: 3951 3950 3311 2 NAND2X1 $T=447120 510600 0 0 $X=446940 $Y=510335
X21900 VSS: 2 VSS: 3830 3621 2 INVX8_HS $T=448960 518880 1 0 $X=448780 $Y=514435
X21908 VSS: 2 VSS: 3953 3952 3951 2568 2 AOI21X1 $T=450340 518880 1 180 $X=447860 $Y=518615
X21927 VSS: 2 VSS: 3909 3491 3912 3954 3756 2 AOI22X1 $T=450340 527160 0 0 $X=450160 $Y=526895
X21936 VSS: 2 VSS: 3784 3911 2 BUFX2 $T=451260 535440 0 180 $X=448780 $Y=530995
X21960 VSS: 2 VSS: 3926 3952 3955 3496 3534 2 AOI22X1_HS $T=451720 543720 1 180 $X=448320 $Y=543455
X21966 VSS: 2 VSS: 3955 7731 816 2325 2 DFFX1_HS $T=442980 552000 1 0 $X=442800 $Y=547555
X21991 VSS: 2 VSS: 3765 3918 2 CLKBUFX4 $T=459540 560280 1 180 $X=456600 $Y=560015
X22006 VSS: 2 VSS: 3917 3957 3956 2 NOR2X2_HS $T=450800 568560 0 0 $X=450620 $Y=568295
X22013 VSS: 2 VSS: 3957 3959 3960 3861 3958 2 NAND4X2_HS $T=443900 576840 1 0 $X=443720 $Y=572395
X22025 VSS: 2 VSS: 3960 3765 3961 3962 960 2 AOI22X2_HS $T=454480 576840 0 0 $X=454300 $Y=576575
X22030 VSS: 2 VSS: 3959 3458 3919 3925 3737 2 AOI22X1_HS $T=449420 585120 0 180 $X=446020 $Y=580675
X22055 VSS: 2 VSS: 3922 3964 3965 2 NOR2X2_HS $T=452180 593400 0 0 $X=452000 $Y=593135
X22063 VSS: 2 VSS: 3924 7732 816 2323 2 DFFX1_HS $T=450340 601680 1 0 $X=450160 $Y=597235
X22084 VSS: 2 VSS: 3966 3930 2320 2558 3836 2 AOI22X1 $T=445740 609960 0 0 $X=445560 $Y=609695
X22102 VSS: 2 VSS: 3930 7733 816 2799 2 DFFX1_HS $T=448960 618240 0 0 $X=448780 $Y=617975
X22109 VSS: 2 VSS: 3967 1982 1676 3864 3930 2 AOI22X2_HS $T=448040 626520 1 0 $X=447860 $Y=622075
X22132 VSS: 2 VSS: 3923 3968 3969 3967 2 NAND3X2_HS $T=452180 634800 0 0 $X=452000 $Y=634535
X22139 VSS: 2 VSS: 3969 3936 3866 3017 3181 2 AOI22X1_HS $T=447580 643080 1 0 $X=447400 $Y=638635
X22153 VSS: 2 VSS: 3722 7734 134 3970 2 DFFX1_HS $T=463220 13800 1 0 $X=463040 $Y=9355
X22160 VSS: 2 VSS: 3730 7735 134 3971 2 DFFX1_HS $T=461380 22080 1 0 $X=461200 $Y=17635
X22167 VSS: 2 VSS: 3797 7736 2871 3971 2 DFFX1_HS $T=468280 22080 0 0 $X=468100 $Y=21815
X22169 VSS: 2 VSS: 3803 7737 2871 3970 2 DFFX1_HS $T=459540 30360 1 0 $X=459360 $Y=25915
X22174 VSS: 2 VSS: 3745 7738 1885 3970 2 DFFX1_HS $T=460460 30360 0 0 $X=460280 $Y=30095
X22178 VSS: 2 VSS: 3659 7739 134 3972 2 DFFX1_HS $T=459540 38640 1 0 $X=459360 $Y=34195
X22182 VSS: 2 VSS: 3736 7740 2871 3972 2 DFFX1_HS $T=462300 38640 0 0 $X=462120 $Y=38375
X22193 VSS: 2 VSS: 3937 3973 3974 2 CLKAND2X2 $T=474260 46920 1 180 $X=471780 $Y=46655
X22200 VSS: 2 VSS: 3973 3976 3873 3658 3975 2 AOI22X2 $T=476100 55200 0 180 $X=471320 $Y=50755
X22205 VSS: 2 VSS: 3806 7741 1885 3971 2 DFFX1_HS $T=467360 55200 0 0 $X=467180 $Y=54935
X22210 VSS: 2 VSS: 3667 7742 1885 3972 2 DFFX1_HS $T=460920 63480 0 0 $X=460740 $Y=63215
X22215 VSS: 2 VSS: 3940 3938 3883 3845 3939 2 AOI22X2 $T=471500 71760 0 180 $X=466720 $Y=67315
X22225 VSS: 2 VSS: 3941 3977 3978 2 CLKAND2X2 $T=465980 80040 0 180 $X=463500 $Y=75595
X22234 VSS: 2 VSS: 3978 3844 3735 3975 3976 2 AOI22X1_HS $T=471960 80040 0 0 $X=471780 $Y=79775
X22245 VSS: 2 VSS: 3974 3979 3672 3847 3980 2 AOI22X2_HS $T=472880 88320 0 0 $X=472700 $Y=88055
X22248 VSS: 2 VSS: 3977 3979 3980 3890 3607 2 AOI22X2_HS $T=465980 96600 1 0 $X=465800 $Y=92155
X22266 VSS: 2 VSS: 3981 3975 3668 3850 3976 2 AOI22X2_HS $T=477020 113160 0 180 $X=471320 $Y=108715
X22272 VSS: 2 VSS: 3975 3852 2 BUFX8_HS $T=474720 113160 0 0 $X=474540 $Y=112895
X22278 VSS: 2 VSS: 3982 3981 4018 2 AND2X1_HS $T=476100 121440 0 180 $X=473160 $Y=116995
X22282 VSS: 2 VSS: 3984 3983 3982 2 NAND2X1_HS $T=469200 121440 1 180 $X=466720 $Y=121175
X22287 VSS: 2 VSS: 3827 3984 2 BUFX8_HS $T=465520 129720 1 0 $X=465340 $Y=125275
X22297 VSS: 2 VSS: 3985 2632 2 CLKBUFX2 $T=464600 138000 1 0 $X=464420 $Y=133555
X22311 VSS: 2 VSS: 3986 wdata_i[18] 1641 1949 3985 2 AOI22X1 $T=470120 146280 1 0 $X=469940 $Y=141835
X22317 VSS: 2 VSS: 3987 1525 wdata_i[18] 2 CLKAND2X2 $T=469200 146280 0 0 $X=469020 $Y=146015
X22325 VSS: 2 VSS: 1166 3989 2 BUFX8_HS $T=461380 510600 1 0 $X=461200 $Y=506155
X22331 VSS: 2 VSS: 3989 3990 2 BUFX2_HS $T=465520 510600 1 180 $X=462580 $Y=510335
X22339 VSS: 2 VSS: 3993 7743 816 2322 2 DFFX1_HS $T=471040 518880 1 0 $X=470860 $Y=514435
X22343 VSS: 2 VSS: 3992 3991 2991 2992 3905 2 AOI22X1 $T=467820 518880 0 0 $X=467640 $Y=518615
X22348 VSS: 2 VSS: 3910 3855 3994 3993 3313 2 AOI22X1 $T=463680 527160 1 0 $X=463500 $Y=522715
X22358 VSS: 2 VSS: 3988 3995 4005 3992 3953 2 NAND4X1_HS $T=477940 527160 1 180 $X=474540 $Y=526895
X22362 VSS: 2 VSS: 3995 3996 2785 2796 3993 2 AOI22X1 $T=467360 535440 1 0 $X=467180 $Y=530995
X22368 VSS: 2 VSS: 3994 7744 816 2017 2 DFFX1_HS $T=469200 535440 0 0 $X=469020 $Y=535175
X22373 VSS: 2 VSS: 3914 704 3994 3993 3687 2 AOI22X2_HS $T=470580 543720 1 0 $X=470400 $Y=539275
X22379 VSS: 2 VSS: 3997 3994 2006 2007 3955 2 AOI22X1 $T=472880 543720 0 0 $X=472700 $Y=543455
X22385 VSS: 2 VSS: 3828 3998 2 BUFX16_HS $T=471960 552000 1 0 $X=471780 $Y=547555
X22387 VSS: 2 VSS: 3409 3998 2 BUFX4_HS $T=466440 552000 1 180 $X=462580 $Y=551735
X22396 VSS: 2 VSS: 3958 3747 3952 3955 3783 2 AOI22X2_HS $T=473800 560280 1 0 $X=473620 $Y=555835
X22405 VSS: 2 VSS: 3329 3980 2 BUFX16_HS $T=480700 568560 0 180 $X=470400 $Y=564115
X22423 VSS: 2 VSS: 3962 7745 816 2802 2 DFFX1_HS $T=463680 585120 1 0 $X=463500 $Y=580675
X22429 VSS: 2 VSS: 3963 3323 3962 3961 1154 2 AOI22X2_HS $T=471040 585120 0 0 $X=470860 $Y=584855
X22441 VSS: 2 VSS: 4001 4031 2317 2343 3962 2 AOI22X1 $T=477940 593400 1 180 $X=475000 $Y=593135
X22450 VSS: 2 VSS: 1154 4032 2 BUFX16_HS $T=478860 601680 1 180 $X=468560 $Y=601415
X22451 VSS: 2 VSS: 4000 3924 2013 2012 3961 2 AOI22X1 $T=464600 609960 0 180 $X=461660 $Y=605515
X22460 VSS: 2 VSS: 4004 4001 4002 4003 3966 2 NAND4X1 $T=474720 609960 1 180 $X=471780 $Y=609695
X22467 VSS: 2 VSS: 4005 4004 4006 3999 2 NOR3X1 $T=472420 618240 1 0 $X=472240 $Y=613795
X22473 VSS: 2 VSS: 4006 4000 4007 3997 4008 2 NAND4X1 $T=473340 618240 0 0 $X=473160 $Y=617975
X22484 VSS: 2 VSS: 4034 1206 3932 2 NAND2X4_HS $T=480240 626520 1 180 $X=475000 $Y=626255
X22489 VSS: 2 VSS: 3968 4009 2 CLKINVX1_HS $T=476560 634800 0 180 $X=473620 $Y=630355
X22500 VSS: 2 VSS: 4009 4034 4036 2 NAND2X2_HS $T=477480 643080 0 180 $X=474080 $Y=638635
X22517 VSS: 2 VSS: 3729 7746 134 4010 2 DFFX1_HS $T=485760 22080 1 0 $X=485580 $Y=17635
X22529 VSS: 2 VSS: 3796 7747 2871 4010 2 DFFX1_HS $T=485760 30360 1 0 $X=485580 $Y=25915
X22537 VSS: 2 VSS: 4012 3502 4013 4011 3828 2 AOI22X1_HS $T=490360 30360 1 180 $X=486960 $Y=30095
X22552 VSS: 2 VSS: 3826 7748 1885 4010 2 DFFX1_HS $T=489440 38640 0 0 $X=489260 $Y=38375
X22555 VSS: 2 VSS: 2555 3038 2 CLKBUFX4 $T=483000 46920 1 0 $X=482820 $Y=42475
X22592 VSS: 2 VSS: 1726 3040 2 CLKBUFX4 $T=487600 63480 0 0 $X=487420 $Y=63215
X22603 VSS: 2 VSS: 3601 3943 3039 3198 4014 2 AOI22X1 $T=487140 71760 1 180 $X=484200 $Y=71495
X22619 VSS: 2 VSS: 3354 7749 134 4015 2 DFFX1_HS $T=482080 88320 1 0 $X=481900 $Y=83875
X22638 VSS: 2 VSS: 3551 7750 134 4016 2 DFFX1_HS $T=479780 96600 0 0 $X=479600 $Y=96335
X22649 VSS: 2 VSS: 3506 7751 2871 4016 2 DFFX1_HS $T=479320 104880 0 0 $X=479140 $Y=104615
X22673 VSS: 2 VSS: 3566 7752 1885 4016 2 DFFX1_HS $T=479780 121440 0 0 $X=479600 $Y=121175
X22686 VSS: 2 VSS: 3390 7753 1885 4015 2 DFFX1_HS $T=482080 129720 0 0 $X=481900 $Y=129455
X22690 VSS: 2 VSS: 4020 4019 2 INVX2 $T=479320 138000 1 0 $X=479140 $Y=133555
X22697 VSS: 2 VSS: 4019 4017 1949 1641 wdata_i[17] 2 AOI22X1 $T=478860 138000 0 0 $X=478680 $Y=137735
X22705 VSS: 2 VSS: 4054 2675 2 CLKBUFX2 $T=491280 146280 1 0 $X=491100 $Y=141835
X22710 VSS: 2 VSS: 4022 3986 2 INVX2 $T=482540 146280 0 0 $X=482360 $Y=146015
X22712 VSS: 2 VSS: 4015 4021 2 CLKBUFX2 $T=486680 146280 1 180 $X=484200 $Y=146015
X22789 VSS: 2 VSS: 4021 4060 2 CLKBUFX8 $T=495420 502320 1 180 $X=490180 $Y=502055
X22791 VSS: 2 VSS: 3870 4024 2 INVX16 $T=486680 510600 0 180 $X=478680 $Y=506155
X22798 VSS: 2 VSS: 3905 7754 816 2571 2 DFFX1_HS $T=480240 510600 0 0 $X=480060 $Y=510335
X22801 VSS: 2 VSS: 2571 4025 2 CLKBUFX8 $T=487140 518880 0 180 $X=481900 $Y=514435
X22803 VSS: 2 VSS: 2322 4061 2 CLKBUFX8 $T=494040 518880 0 180 $X=488800 $Y=514435
X22826 VSS: 2 VSS: 2017 4026 2 CLKBUFX8 $T=488520 535440 0 180 $X=483280 $Y=530995
X22828 VSS: 2 VSS: 2325 4067 2 CLKBUFX8 $T=495420 535440 0 180 $X=490180 $Y=530995
X22836 VSS: 2 VSS: 4024 4027 2 INVX8_HS $T=488520 535440 0 0 $X=488340 $Y=535175
X22839 VSS: 2 VSS: 2023 4028 2 CLKBUFX8 $T=485760 543720 0 180 $X=480520 $Y=539275
X22860 VSS: 2 VSS: 3580 4024 2 INVX16 $T=486220 552000 0 0 $X=486040 $Y=551735
X22872 VSS: 2 VSS: 2995 4024 2 INVX16_HS $T=487600 560280 0 0 $X=487420 $Y=560015
X22882 VSS: 2 VSS: 3330 3980 2 BUFX16_HS $T=478400 568560 0 0 $X=478220 $Y=568295
X22909 VSS: 2 VSS: 3999 3920 3929 4029 4030 2 NAND4X1 $T=479320 593400 0 180 $X=476380 $Y=588955
X22914 VSS: 2 VSS: 3549 4021 2 CLKBUFX8 $T=494500 593400 0 180 $X=489260 $Y=588955
X22925 VSS: 2 VSS: 4030 3932 1701 1726 3954 2 AOI22X1 $T=489900 601680 0 180 $X=486960 $Y=597235
X22938 VSS: 2 VSS: 4003 4033 2555 2564 3925 2 AOI22X1 $T=484380 609960 1 0 $X=484200 $Y=605515
X22984 VSS: 2 VSS: 4002 4035 2606 2808 3936 2 AOI22X1 $T=485300 634800 0 0 $X=485120 $Y=634535
X23003 VSS: 2 VSS: 4040 4039 4012 4038 4037 2 NAND4X4_HS $T=500020 13800 0 0 $X=499840 $Y=13535
X23016 VSS: 2 VSS: 4041 7755 1843 3552 2 DFFX1_HS $T=506000 22080 0 0 $X=505820 $Y=21815
X23028 VSS: 2 VSS: 4042 7756 1843 3504 2 DFFX1_HS $T=506920 30360 0 0 $X=506740 $Y=30095
X23036 VSS: 2 VSS: 4039 3461 4041 4042 3813 2 AOI22X2_HS $T=506920 38640 0 180 $X=501220 $Y=34195
X23050 VSS: 2 VSS: 3877 4043 4044 2 CLKAND2X2 $T=494500 46920 1 180 $X=492020 $Y=46655
X23062 VSS: 2 VSS: 4043 4046 3658 3873 4045 2 AOI22X1_HS $T=504620 55200 0 180 $X=501220 $Y=50755
X23064 VSS: 2 VSS: 1990 3031 2 CLKBUFX4 $T=492200 55200 0 0 $X=492020 $Y=54935
X23074 VSS: 2 VSS: 4044 4048 3878 3846 4047 2 AOI22X1_HS $T=495880 63480 0 180 $X=492480 $Y=59035
X23088 VSS: 2 VSS: 4049 4047 3939 3845 4048 2 AOI22X2 $T=495880 71760 1 0 $X=495700 $Y=67315
X23097 VSS: 2 VSS: 4075 7757 1843 3562 2 DFFX1_HS $T=506920 71760 0 0 $X=506740 $Y=71495
X23106 VSS: 2 VSS: 4050 4045 3844 3735 4046 2 AOI22X2_HS $T=502320 80040 1 0 $X=502140 $Y=75595
X23110 VSS: 2 VSS: 3889 4050 4049 2 CLKAND2X2 $T=501400 80040 1 180 $X=498920 $Y=79775
X23124 VSS: 2 VSS: 4013 7758 1843 4015 2 DFFX1_HS $T=502780 88320 0 0 $X=502600 $Y=88055
X23130 VSS: 2 VSS: 3359 7759 2871 4015 2 DFFX1_HS $T=498180 96600 1 0 $X=498000 $Y=92155
X23139 VSS: 2 VSS: 4079 7760 1843 4016 2 DFFX1_HS $T=506920 96600 0 0 $X=506740 $Y=96335
X23145 VSS: 2 VSS: 3350 4051 2 BUFX16_HS $T=503700 104880 0 180 $X=493400 $Y=100435
X23153 VSS: 2 VSS: 4018 4080 3886 3674 3879 2 AOI22X2_HS $T=511520 104880 1 180 $X=505820 $Y=104615
X23165 VSS: 2 VSS: 4017 2604 2 CLKBUFX2 $T=506460 113160 1 180 $X=503980 $Y=112895
X23172 VSS: 2 VSS: 4052 4048 3851 4014 4047 2 AOI22X1_HS $T=500020 121440 0 180 $X=496620 $Y=116995
X23181 VSS: 2 VSS: 4053 4046 3668 3850 4045 2 AOI22X1_HS $T=506460 121440 1 180 $X=503060 $Y=121175
X23188 VSS: 2 VSS: 3898 4053 4052 2 CLKAND2X2 $T=497720 129720 1 0 $X=497540 $Y=125275
X23192 VSS: 2 VSS: 3504 3397 2 CLKBUFX4 $T=491740 129720 0 0 $X=491560 $Y=129455
X23202 VSS: 2 VSS: 4056 wdata_i[19] 1641 1949 4054 2 AOI22X1 $T=499100 138000 1 0 $X=498920 $Y=133555
X23209 VSS: 2 VSS: 4057 4056 2 INVX2 $T=498640 138000 0 0 $X=498460 $Y=137735
X23221 VSS: 2 VSS: 4085 2864 2 CLKBUFX2 $T=507380 146280 1 0 $X=507200 $Y=141835
X23224 VSS: 2 VSS: 4058 3617 2 CLKBUFX8 $T=493580 146280 0 0 $X=493400 $Y=146015
X23225 VSS: 2 VSS: 4059 410 wdata_i[19] 2 CLKAND2X2 $T=498640 146280 0 0 $X=498460 $Y=146015
X23227 VSS: 2 VSS: 4023 4058 2 CLKBUFX8 $T=504620 146280 0 0 $X=504440 $Y=146015
X23311 VSS: 2 VSS: 3476 3832 2 BUFX16_HS $T=506920 510600 0 180 $X=496620 $Y=506155
X23317 VSS: 2 VSS: 3747 3990 2 BUFX8_HS $T=505080 510600 0 0 $X=504900 $Y=510335
X23324 VSS: 2 VSS: 4047 4062 2 INVX16_HS $T=508760 518880 0 180 $X=500300 $Y=514435
X23325 VSS: 2 VSS: 3621 4064 4063 2 NOR2X4_HS $T=497720 518880 1 180 $X=492480 $Y=518615
X23333 VSS: 2 VSS: 3833 4065 4063 2 NOR2X4_HS $T=499100 527160 0 180 $X=493860 $Y=522715
X23341 VSS: 2 VSS: 4066 4063 2 INVX4_HS $T=504620 527160 1 180 $X=501220 $Y=526895
X23346 VSS: 2 VSS: 3954 8166 816 135 2014 2 DFFRX1_HS $T=495420 535440 1 0 $X=495240 $Y=530995
X23352 VSS: 2 VSS: 4069 4068 2 INVX4 $T=508760 535440 1 180 $X=506280 $Y=535175
X23362 VSS: 2 VSS: 4027 4093 4068 2 NOR2X4_HS $T=511980 543720 0 180 $X=506740 $Y=539275
X23366 VSS: 2 VSS: 3838 4069 4066 2 NAND2X4_HS $T=505080 543720 1 180 $X=499840 $Y=543455
X23405 VSS: 2 VSS: 3403 4062 2 INVX8_HS $T=506460 568560 0 0 $X=506280 $Y=568295
X23411 VSS: 2 VSS: 2802 4070 2 CLKBUFX8 $T=504160 576840 0 180 $X=498920 $Y=572395
X23417 VSS: 2 VSS: 3840 4071 2 INVX16_HS $T=502780 576840 1 180 $X=494320 $Y=576575
X23423 VSS: 2 VSS: 1683 4071 2 INVX16_HS $T=501400 585120 0 180 $X=492940 $Y=580675
X23433 VSS: 2 VSS: 4072 3838 2 BUFX16_HS $T=504620 593400 0 180 $X=494320 $Y=588955
X23448 VSS: 2 VSS: 1210 4051 2 BUFX8_HS $T=502780 601680 1 180 $X=497080 $Y=601415
X23458 VSS: 2 VSS: 4033 7761 816 3459 2 DFFX1_HS $T=503240 609960 1 0 $X=503060 $Y=605515
X23461 VSS: 2 VSS: 3866 7762 816 3549 2 DFFX1_HS $T=495420 609960 0 0 $X=495240 $Y=609695
X23470 VSS: 2 VSS: 4008 3866 3022 3205 4073 2 AOI22X1 $T=502780 618240 0 180 $X=499840 $Y=613795
X23475 VSS: 2 VSS: 3961 7763 816 4074 2 DFFX1_HS $T=498180 618240 0 0 $X=498000 $Y=617975
X23484 VSS: 2 VSS: 4074 3713 2 CLKBUFX4 $T=508300 626520 0 180 $X=505360 $Y=622075
X23488 VSS: 2 VSS: 3934 2595 4107 4035 2596 2 AOI22X1_HS $T=509220 626520 1 180 $X=505820 $Y=626255
X23496 VSS: 2 VSS: 3936 7764 816 3548 2 DFFX1_HS $T=504620 634800 1 0 $X=504440 $Y=630355
X23502 VSS: 2 VSS: 3925 7765 816 2578 2 DFFX1_HS $T=504160 634800 0 0 $X=503980 $Y=634535
X23516 VSS: 2 VSS: 4037 4075 3350 2 NAND2X4_HS $T=515200 13800 0 180 $X=509960 $Y=9355
X23533 VSS: 2 VSS: 4011 7766 1843 3874 2 DFFX1_HS $T=509680 30360 1 0 $X=509500 $Y=25915
X23549 VSS: 2 VSS: 1991 2825 2 CLKBUFX4 $T=511980 46920 1 0 $X=511800 $Y=42475
X23555 VSS: 2 VSS: 3845 7767 2871 4076 2 DFFX1_HS $T=510600 46920 0 0 $X=510420 $Y=46655
X23564 VSS: 2 VSS: 3851 7768 1885 4076 2 DFFX1_HS $T=524400 55200 1 0 $X=524220 $Y=50755
X23565 VSS: 2 VSS: 3878 7769 134 4076 2 DFFX1_HS $T=508760 55200 0 0 $X=508580 $Y=54935
X23571 VSS: 2 VSS: 4077 4075 3034 3040 4078 2 AOI22X1 $T=521180 63480 0 180 $X=518240 $Y=59035
X23575 VSS: 2 VSS: 1701 3034 2 CLKBUFX4 $T=512900 63480 0 0 $X=512720 $Y=63215
X23600 VSS: 2 VSS: 3658 7770 134 4115 2 DFFX1_HS $T=523480 88320 1 0 $X=523300 $Y=83875
X23638 VSS: 2 VSS: 3355 4081 2 BUFX16_HS $T=522560 129720 0 180 $X=512260 $Y=125275
X23644 VSS: 2 VSS: 4081 4082 2 BUFX2_HS $T=516120 129720 0 0 $X=515940 $Y=129455
X23652 VSS: 2 VSS: 4083 2687 2 CLKBUFX2 $T=522560 138000 1 0 $X=522380 $Y=133555
X23656 VSS: 2 VSS: 4086 4085 1949 1641 wdata_i[21] 2 AOI22X1 $T=514280 138000 0 0 $X=514100 $Y=137735
X23662 VSS: 2 VSS: 4088 4086 2 INVX2 $T=517040 146280 1 0 $X=516860 $Y=141835
X23663 VSS: 2 VSS: 3397 4087 2 CLKBUFX8 $T=523480 146280 0 180 $X=518240 $Y=141835
X23665 VSS: 2 VSS: 3017 4082 2 BUFX8_HS $T=515200 146280 1 180 $X=509500 $Y=146015
X23671 VSS: 2 VSS: 3461 4089 2 BUFX16_HS $T=512900 502320 0 0 $X=512720 $Y=502055
X23675 VSS: 2 VSS: 3903 7771 816 2321 2 DFFX1_HS $T=516120 510600 1 0 $X=515940 $Y=506155
X23679 VSS: 2 VSS: 3756 4090 2 INVX16_HS $T=515660 510600 0 0 $X=515480 $Y=510335
X23689 VSS: 2 VSS: 4090 4092 4091 2 NAND2X4_HS $T=520260 518880 1 180 $X=515020 $Y=518615
X23697 VSS: 2 VSS: 3952 7772 816 2570 2 DFFX1_HS $T=523940 527160 1 0 $X=523760 $Y=522715
X23703 VSS: 2 VSS: 4092 4068 2 CLKINVX2 $T=523480 527160 1 180 $X=521920 $Y=526895
X23709 VSS: 2 VSS: 3501 4126 2 INVX16_HS $T=531760 535440 0 180 $X=523300 $Y=530995
X23719 VSS: 2 VSS: 4127 3832 2 BUFX16_HS $T=531760 543720 0 180 $X=521460 $Y=539275
X23727 VSS: 2 VSS: 3641 4094 2 CLKBUFX2 $T=518420 552000 0 180 $X=515940 $Y=547555
X23731 VSS: 2 VSS: 3998 4068 4095 2 NOR2X4_HS $T=509680 552000 0 0 $X=509500 $Y=551735
X23736 VSS: 2 VSS: 4096 3998 2 BUFX8_HS $T=510600 560280 1 0 $X=510420 $Y=555835
X23741 VSS: 2 VSS: 3991 7773 816 3455 2 DFFX1_HS $T=511060 560280 0 0 $X=510880 $Y=560015
X23745 VSS: 2 VSS: 4089 4064 4095 2 NOR2X4_HS $T=513820 568560 1 0 $X=513640 $Y=564115
X23752 VSS: 2 VSS: 3785 4062 2 INVX8_HS $T=526700 568560 1 180 $X=521460 $Y=568295
X23754 VSS: 2 VSS: 4071 4089 2 INVX8_HS $T=511980 576840 1 0 $X=511800 $Y=572395
X23769 VSS: 2 VSS: 4098 3327 3991 4097 3329 2 AOI22X2_HS $T=522560 585120 1 180 $X=516860 $Y=584855
X23771 VSS: 2 VSS: 2323 4100 2 CLKBUFX8 $T=513360 593400 0 180 $X=508120 $Y=588955
X23775 VSS: 2 VSS: 4101 3195 3996 4031 3196 2 AOI22X2_HS $T=521640 593400 1 0 $X=521460 $Y=588955
X23780 VSS: 2 VSS: 3956 4099 4102 4131 4132 2 NAND4X4_HS $T=520720 593400 0 0 $X=520540 $Y=593135
X23784 VSS: 2 VSS: 3965 4103 4104 4098 4101 2 NAND4X4_HS $T=516580 601680 1 0 $X=516400 $Y=597235
X23798 VSS: 2 VSS: 4073 7774 816 3538 2 DFFX1_HS $T=522100 609960 0 0 $X=521920 $Y=609695
X23809 VSS: 2 VSS: 2578 4106 2 CLKBUFX8 $T=515660 626520 0 180 $X=510420 $Y=622075
X23812 VSS: 2 VSS: 3713 4105 2 CLKBUFX2 $T=520720 626520 0 180 $X=518240 $Y=622075
X23830 VSS: 2 VSS: 4036 4035 4107 2544 2600 2 AOI22X2_HS $T=522100 643080 0 180 $X=516400 $Y=638635
X23838 VSS: 2 VSS: 4108 4075 1206 2 NAND2X1 $T=538660 13800 1 0 $X=538480 $Y=9355
X23853 VSS: 2 VSS: 4038 3501 4109 4079 3508 2 AOI22X2_HS $T=529460 22080 1 0 $X=529280 $Y=17635
X23864 VSS: 2 VSS: 4110 3466 4042 4041 3465 2 AOI22X2 $T=544640 22080 1 180 $X=539860 $Y=21815
X23878 VSS: 2 VSS: 3873 7775 134 4111 2 DFFX1_HS $T=535440 30360 0 0 $X=535260 $Y=30095
X23885 VSS: 2 VSS: 3844 7776 2871 4111 2 DFFX1_HS $T=536360 38640 1 0 $X=536180 $Y=34195
X23892 VSS: 2 VSS: 3850 7777 1885 4111 2 DFFX1_HS $T=535900 38640 0 0 $X=535720 $Y=38375
X23901 VSS: 2 VSS: 4113 4112 2825 3031 4042 2 AOI22X1 $T=540960 46920 0 180 $X=538020 $Y=42475
X23946 VSS: 2 VSS: 3847 7778 134 4114 2 DFFX1_HS $T=529460 71760 1 0 $X=529280 $Y=67315
X23953 VSS: 2 VSS: 3890 7779 2871 4114 2 DFFX1_HS $T=529920 71760 0 0 $X=529740 $Y=71495
X23966 VSS: 2 VSS: 3943 7780 1885 4114 2 DFFX1_HS $T=528080 80040 0 0 $X=527900 $Y=79775
X23980 VSS: 2 VSS: 3735 7781 2871 4115 2 DFFX1_HS $T=531300 88320 0 0 $X=531120 $Y=88055
X23985 VSS: 2 VSS: 3742 7782 2871 4116 2 DFFX1_HS $T=525780 96600 1 0 $X=525600 $Y=92155
X24008 VSS: 2 VSS: 3674 7783 1885 4116 2 DFFX1_HS $T=526700 104880 0 0 $X=526520 $Y=104615
X24025 VSS: 2 VSS: 4117 3979 3677 3943 3980 2 AOI22X2_HS $T=538200 113160 1 180 $X=532500 $Y=112895
X24032 VSS: 2 VSS: 3668 7784 1885 4115 2 DFFX1_HS $T=529920 121440 1 0 $X=529740 $Y=116995
X24039 VSS: 2 VSS: 4118 2839 2 CLKBUFX2 $T=527620 121440 0 0 $X=527440 $Y=121175
X24074 VSS: 2 VSS: 4120 wdata_i[24] 1641 1949 4083 2 AOI22X1 $T=537740 138000 0 0 $X=537560 $Y=137735
X24081 VSS: 2 VSS: 4121 4118 1949 1641 wdata_i[22] 2 AOI22X1 $T=532680 146280 1 0 $X=532500 $Y=141835
X24090 VSS: 2 VSS: 4122 4121 2 INVX2 $T=535440 146280 0 0 $X=535260 $Y=146015
X24240 VSS: 2 VSS: 3186 4123 2 BUFX16_HS $T=543260 502320 1 180 $X=532960 $Y=502055
X24248 VSS: 2 VSS: 3912 7785 816 2005 2 DFFX1_HS $T=536820 510600 1 0 $X=536640 $Y=506155
X24268 VSS: 2 VSS: 4091 4124 2 INVX2 $T=530380 518880 1 180 $X=528820 $Y=518615
X24272 VSS: 2 VSS: 4045 4123 2 BUFX16_HS $T=533600 518880 0 0 $X=533420 $Y=518615
X24290 VSS: 2 VSS: 2014 4125 2 CLKBUFX8 $T=536820 535440 0 180 $X=531580 $Y=530995
X24297 VSS: 2 VSS: 3832 4068 4124 2 NOR2X4_HS $T=526240 535440 0 0 $X=526060 $Y=535175
X24313 VSS: 2 VSS: 2596 4126 2 INVX16_HS $T=534980 543720 1 180 $X=526520 $Y=543455
X24321 VSS: 2 VSS: 3495 4128 2 CLKBUFX4 $T=529920 552000 0 180 $X=526980 $Y=547555
X24331 VSS: 2 VSS: 4129 4065 4124 2 NOR2X4_HS $T=538660 552000 1 180 $X=533420 $Y=551735
X24344 VSS: 2 VSS: 3737 4129 2 BUFX16_HS $T=538200 560280 1 180 $X=527900 $Y=560015
X24373 VSS: 2 VSS: 3859 4129 2 BUFX16_HS $T=536820 576840 1 180 $X=526520 $Y=576575
X24379 VSS: 2 VSS: 4029 4097 3039 3198 4130 2 AOI22X1 $T=528080 585120 0 180 $X=525140 $Y=580675
X24418 VSS: 2 VSS: 4103 4073 4033 4133 3190 2 AOI22X1_HS $T=526240 601680 0 0 $X=526060 $Y=601415
X24443 VSS: 2 VSS: 4102 3654 4073 4033 2988 2 AOI22X2_HS $T=535440 618240 0 180 $X=529740 $Y=613795
X24453 VSS: 2 VSS: 4007 4107 3028 3029 4134 2 AOI22X1 $T=533600 618240 1 180 $X=530660 $Y=617975
X24460 VSS: 2 VSS: 3654 4045 2 BUFX16_HS $T=536820 626520 0 180 $X=526520 $Y=622075
X24467 VSS: 2 VSS: 4107 7786 816 3499 2 DFFX1_HS $T=526240 626520 0 0 $X=526060 $Y=626255
X24483 VSS: 2 VSS: 4035 7787 816 3547 2 DFFX1_HS $T=527620 634800 0 0 $X=527440 $Y=634535
X24522 VSS: 2 VSS: 4109 7788 1843 3770 2 DFFX1_HS $T=544640 30360 1 0 $X=544460 $Y=25915
X24541 VSS: 2 VSS: 4135 7789 1843 4076 2 DFFX1_HS $T=540960 46920 0 0 $X=540780 $Y=46655
X24549 VSS: 2 VSS: 3868 7790 134 4136 2 DFFX1_HS $T=551540 55200 1 0 $X=551360 $Y=50755
X24551 VSS: 2 VSS: 3872 7791 2871 4136 2 DFFX1_HS $T=547400 55200 0 0 $X=547220 $Y=54935
X24556 VSS: 2 VSS: 3879 7792 1885 4136 2 DFFX1_HS $T=548320 63480 1 0 $X=548140 $Y=59035
X24569 VSS: 2 VSS: 3939 7793 2871 4137 2 DFFX1_HS $T=550160 71760 0 0 $X=549980 $Y=71495
X24573 VSS: 2 VSS: 3846 7794 134 4137 2 DFFX1_HS $T=549240 80040 1 0 $X=549060 $Y=75595
X24578 VSS: 2 VSS: 4014 7795 1885 4137 2 DFFX1_HS $T=549700 80040 0 0 $X=549520 $Y=79775
X24589 VSS: 2 VSS: 3607 7796 2871 4138 2 DFFX1_HS $T=547860 96600 1 0 $X=547680 $Y=92155
X24594 VSS: 2 VSS: 4112 7797 1843 3385 2 DFFX1_HS $T=552920 96600 0 0 $X=552740 $Y=96335
X24596 VSS: 2 VSS: 3673 7798 134 4116 2 DFFX1_HS $T=544640 104880 1 0 $X=544460 $Y=100435
X24600 VSS: 2 VSS: 3677 7799 1885 4138 2 DFFX1_HS $T=547860 104880 0 0 $X=547680 $Y=104615
X24619 VSS: 2 VSS: 3983 4139 4117 2 AND2X1_HS $T=547860 121440 0 0 $X=547680 $Y=121175
X24629 VSS: 2 VSS: 3437 4140 2 BUFX8 $T=547400 129720 1 180 $X=542160 $Y=129455
X24637 VSS: 2 VSS: 4143 4142 1949 1641 wdata_i[28] 2 AOI22X2_HS $T=558440 138000 0 180 $X=552740 $Y=133555
X24647 VSS: 2 VSS: 4144 4143 2 INVX4_HS $T=552920 146280 1 0 $X=552740 $Y=141835
X24649 VSS: 2 VSS: 3519 4145 2 CLKBUFX8 $T=542340 146280 0 0 $X=542160 $Y=146015
X24650 VSS: 2 VSS: 4146 4120 2 INVX2 $T=547400 146280 0 0 $X=547220 $Y=146015
X24652 VSS: 2 VSS: 3839 4145 2 CLKBUFX8 $T=554300 146280 1 180 $X=549060 $Y=146015
X24666 VSS: 2 VSS: 3204 4147 2 BUFX4 $T=552460 510600 1 180 $X=549520 $Y=510335
X24671 VSS: 2 VSS: 3531 4148 2 INVX16_HS $T=554300 518880 0 180 $X=545840 $Y=514435
X24680 VSS: 2 VSS: 4148 4063 4182 2 NOR2X4_HS $T=555220 527160 1 0 $X=555040 $Y=522715
X24686 VSS: 2 VSS: 4180 4068 4149 2 NOR2X2_HS $T=560280 527160 1 180 $X=556880 $Y=526895
X24690 VSS: 2 VSS: 4149 4063 2 BUFX2_HS $T=552000 535440 1 0 $X=551820 $Y=530995
X24695 VSS: 2 VSS: 4063 4150 4151 2 NAND2X4_HS $T=556600 535440 1 180 $X=551360 $Y=535175
X24700 VSS: 2 VSS: 4151 4153 4152 2 NOR2X4_HS $T=551080 543720 1 0 $X=550900 $Y=539275
X24704 VSS: 2 VSS: 4126 4154 2 INVX8_HS $T=544640 543720 0 0 $X=544460 $Y=543455
X24709 VSS: 2 VSS: 4062 4155 2 INVX8_HS $T=547860 552000 0 180 $X=542620 $Y=547555
X24721 VSS: 2 VSS: 4124 4152 4153 4156 2 NAND3X4_HS $T=555220 560280 0 180 $X=548140 $Y=555835
X24725 VSS: 2 VSS: 4157 4153 4152 2 NOR2X4_HS $T=549240 560280 0 0 $X=549060 $Y=560015
X24730 VSS: 2 VSS: 4095 4156 4157 2 NAND2X4_HS $T=554300 568560 0 180 $X=549060 $Y=564115
X24735 VSS: 2 VSS: 4158 4065 4095 2 NOR2X4_HS $T=544640 568560 0 0 $X=544460 $Y=568295
X24742 VSS: 2 VSS: 4156 4150 2 INVX8_HS $T=554300 576840 0 180 $X=549060 $Y=572395
X24744 VSS: 2 VSS: 3810 4158 2 BUFX16_HS $T=544180 576840 0 0 $X=544000 $Y=576575
X24747 VSS: 2 VSS: 1690 4158 2 BUFX16_HS $T=546480 585120 1 0 $X=546300 $Y=580675
X24751 VSS: 2 VSS: 4099 4159 4097 3991 4160 2 AOI22X1 $T=549240 585120 1 180 $X=546300 $Y=584855
X24765 VSS: 2 VSS: 4160 4186 2 CLKBUFX2 $T=558900 593400 1 180 $X=556420 $Y=593135
X24773 VSS: 2 VSS: 4131 4161 4134 4130 3785 2 AOI22X1_HS $T=550620 601680 0 0 $X=550440 $Y=601415
X24775 VSS: 2 VSS: 4104 3401 4162 4134 4130 2 AOI22X2_HS $T=541880 609960 1 0 $X=541700 $Y=605515
X24780 VSS: 2 VSS: 4134 7800 816 3498 2 DFFX1_HS $T=543260 609960 0 0 $X=543080 $Y=609695
X24791 VSS: 2 VSS: 2988 4163 2 BUFX4_HS $T=556140 618240 1 180 $X=552280 $Y=617975
X24798 VSS: 2 VSS: 4164 4186 2 BUFX8_HS $T=560280 626520 0 180 $X=554580 $Y=622075
X24807 VSS: 2 VSS: 4191 4164 2 BUFX16_HS $T=563040 634800 0 180 $X=552740 $Y=630355
X24810 VSS: 2 VSS: 2978 4164 2 BUFX16_HS $T=561660 634800 1 180 $X=551360 $Y=634535
X24816 VSS: 2 VSS: 4166 4108 4165 2 AND2X1_HS $T=558440 13800 1 0 $X=558260 $Y=9355
X24827 VSS: 2 VSS: 4165 3500 4079 4109 3505 2 AOI22X2_HS $T=570400 13800 1 180 $X=564700 $Y=13535
X24833 VSS: 2 VSS: 4167 4109 2606 2808 4011 2 AOI22X1 $T=570400 22080 0 180 $X=567460 $Y=17635
X24853 VSS: 2 VSS: 4168 3355 4013 4011 3356 2 AOI22X1_HS $T=565340 30360 0 0 $X=565160 $Y=30095
X24857 VSS: 2 VSS: 4170 4079 3028 3029 4135 2 AOI22X1 $T=563960 38640 1 0 $X=563780 $Y=34195
X24858 VSS: 2 VSS: 3770 4169 2 CLKBUFX4 $T=569480 38640 0 180 $X=566540 $Y=34195
X24870 VSS: 2 VSS: 2320 3230 2 CLKBUFX4 $T=563960 46920 1 0 $X=563780 $Y=42475
X24881 VSS: 2 VSS: 2558 3225 2 CLKBUFX4 $T=572240 46920 0 0 $X=572060 $Y=46655
X24905 VSS: 2 VSS: 4171 3938 3883 4135 4172 2 AOI22X2_HS $T=568560 63480 0 0 $X=568380 $Y=63215
X24910 VSS: 2 VSS: 4202 4047 4172 4135 4048 2 AOI22X2_HS $T=570400 71760 1 0 $X=570220 $Y=67315
X24940 VSS: 2 VSS: 4173 7801 1843 4115 2 DFFX1_HS $T=562580 88320 0 0 $X=562400 $Y=88055
X24945 VSS: 2 VSS: 3672 7178 134 4138 2 DFFX4_HS $T=569020 96600 1 0 $X=568840 $Y=92155
X24970 VSS: 2 VSS: 4205 3644 2 BUFX16_HS $T=580520 113160 0 180 $X=570220 $Y=108715
X24983 VSS: 2 VSS: 3883 4209 2 BUFX8_HS $T=578680 121440 0 180 $X=572980 $Y=116995
X24990 VSS: 2 VSS: 3896 4174 2 CLKBUFX4 $T=563960 121440 0 0 $X=563780 $Y=121175
X24994 VSS: 2 VSS: 4139 4014 3851 4209 4206 2 AOI22X1_HS $T=572700 121440 0 0 $X=572520 $Y=121175
X24996 VSS: 2 VSS: 4175 3458 2 BUFX16_HS $T=568560 129720 0 180 $X=558260 $Y=125275
X25008 VSS: 2 VSS: 4210 2612 2 CLKBUFX2 $T=572240 129720 0 0 $X=572060 $Y=129455
X25018 VSS: 2 VSS: 4142 4176 2 CLKBUFX2 $T=558440 138000 0 0 $X=558260 $Y=137735
X25032 VSS: 2 VSS: 4178 1525 wdata_i[24] 2 CLKAND2X2 $T=560280 146280 0 0 $X=560100 $Y=146015
X25035 VSS: 2 VSS: 4076 4177 2 CLKBUFX4 $T=569480 146280 1 180 $X=566540 $Y=146015
X25108 VSS: 2 VSS: 4176 2618 2 CLKBUFX2 $T=557520 502320 0 0 $X=557340 $Y=502055
X25113 VSS: 2 VSS: 2570 4174 2 CLKBUFX8 $T=563960 510600 0 180 $X=558720 $Y=506155
X25114 VSS: 2 VSS: 4179 4180 2 BUFX16_HS $T=563960 510600 1 0 $X=563780 $Y=506155
X25122 VSS: 2 VSS: 4048 4181 2 BUFX8_HS $T=574080 510600 1 180 $X=568380 $Y=510335
X25133 VSS: 2 VSS: 4147 4124 4182 2 NOR2X4_HS $T=562580 518880 0 0 $X=562400 $Y=518615
X25151 VSS: 2 VSS: 4181 3911 2 BUFX8_HS $T=573160 535440 0 180 $X=567460 $Y=530995
X25168 VSS: 2 VSS: 3458 4183 2 BUFX16_HS $T=571780 543720 1 180 $X=561480 $Y=543455
X25172 VSS: 2 VSS: 4154 4184 4093 2 NOR2X4_HS $T=565340 552000 0 180 $X=560100 $Y=547555
X25180 VSS: 2 VSS: 4183 4184 4124 2 NOR2X4_HS $T=569480 552000 1 180 $X=564240 $Y=551735
X25193 VSS: 2 VSS: 3644 4185 2 INVX8_HS $T=574080 560280 1 180 $X=568840 $Y=560015
X25207 VSS: 2 VSS: 4185 4186 2 INVX4_HS $T=570400 568560 0 0 $X=570220 $Y=568295
X25218 VSS: 2 VSS: 3843 4187 2 CLKBUFX8_HS $T=571320 576840 1 180 $X=562400 $Y=576575
X25229 VSS: 2 VSS: 4189 4188 2 BUFX2_HS $T=570400 585120 1 180 $X=567460 $Y=584855
X25232 VSS: 2 VSS: 4132 3580 4031 3996 4189 2 AOI22X2_HS $T=561200 593400 1 0 $X=561020 $Y=588955
X25245 VSS: 2 VSS: 4227 7802 1926 3538 2 DFFX1_HS $T=567640 601680 1 0 $X=567460 $Y=597235
X25254 VSS: 2 VSS: 4228 7179 2945 3538 2 DFFX4_HS $T=571320 601680 0 0 $X=571140 $Y=601415
X25265 VSS: 2 VSS: 4190 7180 2945 3498 2 DFFX4_HS $T=560740 609960 0 0 $X=560560 $Y=609695
X25283 VSS: 2 VSS: 3547 4169 2 CLKBUFX8 $T=576840 626520 0 180 $X=571600 $Y=622075
X25329 VSS: 2 VSS: 4192 4166 4168 4110 2 NAND3X2_HS $T=574540 22080 0 0 $X=574360 $Y=21815
X25340 VSS: 2 VSS: 4240 4195 4167 4193 4194 2 NAND4X1 $T=587880 30360 1 0 $X=587700 $Y=25915
X25346 VSS: 2 VSS: 4194 4041 3230 3225 4196 2 AOI22X1 $T=589260 30360 1 180 $X=586320 $Y=30095
X25358 VSS: 2 VSS: 4193 4173 3038 2603 4197 2 AOI22X1 $T=580060 38640 0 0 $X=579880 $Y=38375
X25369 VSS: 2 VSS: 4242 7803 1843 4111 2 DFFX1_HS $T=589260 46920 1 0 $X=589080 $Y=42475
X25383 VSS: 2 VSS: 4198 4045 4242 4173 4046 2 AOI22X1_HS $T=592020 55200 0 180 $X=588620 $Y=50755
X25389 VSS: 2 VSS: 4200 4199 4113 4201 4077 2 NAND4X1 $T=585580 55200 0 0 $X=585400 $Y=54935
X25415 VSS: 2 VSS: 4201 4203 3039 3198 4172 2 AOI22X1 $T=576840 71760 0 0 $X=576660 $Y=71495
X25426 VSS: 2 VSS: 4247 3180 4203 4204 4208 2 AOI22X2 $T=588340 80040 1 0 $X=588160 $Y=75595
X25428 VSS: 2 VSS: 4172 7804 1843 4137 2 DFFX1_HS $T=577300 80040 0 0 $X=577120 $Y=79775
X25436 VSS: 2 VSS: 4078 7805 1843 3516 2 DFFX1_HS $T=580060 88320 1 0 $X=579880 $Y=83875
X25462 VSS: 2 VSS: 3518 4207 2 BUFX8_HS $T=585580 104880 1 180 $X=579880 $Y=104615
X25473 VSS: 2 VSS: 4208 3644 2 BUFX16_HS $T=577760 113160 0 0 $X=577580 $Y=112895
X25505 VSS: 2 VSS: 4211 wdata_i[27] 1641 1949 4251 2 AOI22X1 $T=591100 138000 0 180 $X=588160 $Y=133555
X25509 VSS: 2 VSS: 4212 wdata_i[26] 1641 1949 4210 2 AOI22X1 $T=578220 138000 0 0 $X=578040 $Y=137735
X25519 VSS: 2 VSS: 4213 4212 2 INVX2 $T=577760 146280 1 0 $X=577580 $Y=141835
X25524 VSS: 2 VSS: 4214 4211 2 INVX2 $T=590180 146280 0 180 $X=588620 $Y=141835
X25529 VSS: 2 VSS: 4215 410 wdata_i[17] 2 CLKAND2X2 $T=586960 146280 0 0 $X=586780 $Y=146015
X25607 VSS: 2 VSS: 4169 4217 2 CLKBUFX8 $T=577300 502320 0 0 $X=577120 $Y=502055
X25608 VSS: 2 VSS: 3741 4257 2 BUFX16_HS $T=592480 502320 1 180 $X=582180 $Y=502055
X25617 VSS: 2 VSS: 4174 4218 2 CLKBUFX4 $T=587420 510600 0 180 $X=584480 $Y=506155
X25621 VSS: 2 VSS: 4207 4219 2 BUFX16_HS $T=588340 510600 1 180 $X=578040 $Y=510335
X25622 VSS: 2 VSS: 4258 4181 2 BUFX16_HS $T=588340 510600 0 0 $X=588160 $Y=510335
X25627 VSS: 2 VSS: 3790 4147 2 BUFX16_HS $T=575460 518880 1 0 $X=575280 $Y=514435
X25645 VSS: 2 VSS: 3911 4220 4064 2 NOR2X4_HS $T=579600 527160 0 0 $X=579420 $Y=526895
X25652 VSS: 2 VSS: 4221 3911 2 BUFX8_HS $T=578680 535440 1 0 $X=578500 $Y=530995
X25656 VSS: 2 VSS: 4123 4068 4220 2 NOR2X4_HS $T=578680 535440 0 0 $X=578500 $Y=535175
X25665 VSS: 2 VSS: 4186 4220 4222 2 NOR2X4_HS $T=579140 543720 1 0 $X=578960 $Y=539275
X25671 VSS: 2 VSS: 4094 4225 2 BUFX16_HS $T=593860 543720 1 180 $X=583560 $Y=543455
X25675 VSS: 2 VSS: 4216 4183 2 BUFX16_HS $T=573620 552000 1 0 $X=573440 $Y=547555
X25686 VSS: 2 VSS: 4161 4181 2 BUFX16_HS $T=575460 560280 1 0 $X=575280 $Y=555835
X25693 VSS: 2 VSS: 4223 4185 2 INVX8_HS $T=584200 560280 0 0 $X=584020 $Y=560015
X25700 VSS: 2 VSS: 4187 4222 4224 2 NOR2X4_HS $T=581900 568560 1 0 $X=581720 $Y=564115
X25713 VSS: 2 VSS: 4188 3531 2 CLKINVX8 $T=579600 576840 1 0 $X=579420 $Y=572395
X25720 VSS: 2 VSS: 3180 4225 2 BUFX8_HS $T=588340 576840 1 180 $X=582640 $Y=576575
X25727 VSS: 2 VSS: 4051 4187 2 BUFX16_HS $T=577760 585120 1 0 $X=577580 $Y=580675
X25743 VSS: 2 VSS: 4226 7181 3904 3538 2 DFFX4_HS $T=574540 593400 0 0 $X=574360 $Y=593135
X25762 VSS: 2 VSS: 4130 7806 816 4268 2 DFFX1_HS $T=588800 609960 1 0 $X=588620 $Y=605515
X25765 VSS: 2 VSS: 4229 7807 1926 3498 2 DFFX1_HS $T=581440 609960 0 0 $X=581260 $Y=609695
X25772 VSS: 2 VSS: 4230 7182 3904 3498 2 DFFX4_HS $T=581900 618240 1 0 $X=581720 $Y=613795
X25778 VSS: 2 VSS: 4231 4163 2 CLKBUFX2_HS $T=583280 618240 0 0 $X=583100 $Y=617975
X25786 VSS: 2 VSS: 4233 4231 4232 4226 4045 2 AOI22X2_HS $T=585120 626520 1 0 $X=584940 $Y=622075
X25792 VSS: 2 VSS: 4235 4233 4234 2 AND2X1_HS $T=586500 626520 0 0 $X=586320 $Y=626255
X25801 VSS: 2 VSS: 4270 4235 4269 2 NAND2X4_HS $T=586960 634800 1 0 $X=586780 $Y=630355
X25812 VSS: 2 VSS: 4234 4161 4230 4236 3403 2 AOI22X2_HS $T=584660 643080 1 0 $X=584480 $Y=638635
X25821 VSS: 2 VSS: 2938 4238 2 BUFX16_HS $T=602600 13800 1 0 $X=602420 $Y=9355
X25827 VSS: 2 VSS: 4238 4271 4239 2 NAND2X2_HS $T=609500 13800 1 180 $X=606100 $Y=13535
X25829 VSS: 2 VSS: 2564 2603 2 CLKBUFX4 $T=591100 22080 1 0 $X=590920 $Y=17635
X25849 VSS: 2 VSS: 4275 4240 4241 4200 2 NOR3X1 $T=606280 30360 0 0 $X=606100 $Y=30095
X25850 VSS: 2 VSS: 4243 4013 3022 3205 4242 2 AOI22X1 $T=592940 38640 0 180 $X=590000 $Y=34195
X25860 VSS: 2 VSS: 4241 4244 4170 4245 4243 2 NAND4X1 $T=606740 38640 1 180 $X=603800 $Y=38375
X25865 VSS: 2 VSS: 4246 4202 4198 2 AND2X1_HS $T=595240 46920 0 0 $X=595060 $Y=46655
X25875 VSS: 2 VSS: 4279 4276 4247 4246 2 NAND3X2_HS $T=606280 55200 1 0 $X=606100 $Y=50755
X25880 VSS: 2 VSS: 4248 4242 4173 3975 3976 2 AOI22X1 $T=590180 63480 1 0 $X=590000 $Y=59035
X25894 VSS: 2 VSS: 4203 7808 1843 4114 2 DFFX1_HS $T=603980 71760 1 0 $X=603800 $Y=67315
X25900 VSS: 2 VSS: 4282 4284 3980 4203 4204 2 AOI22X2 $T=606280 71760 0 0 $X=606100 $Y=71495
X25915 VSS: 2 VSS: rdata_o[4] 3611 2 BUFX2 $T=590640 88320 0 0 $X=590460 $Y=88055
X25921 VSS: 2 VSS: 3938 4206 2 BUFX8_HS $T=595240 96600 1 0 $X=595060 $Y=92155
X25933 VSS: 2 VSS: 4204 7809 1843 4138 2 DFFX1_HS $T=597540 104880 1 0 $X=597360 $Y=100435
X25952 VSS: 2 VSS: 4251 2620 2 CLKBUFX2 $T=598920 121440 0 180 $X=596440 $Y=116995
X25958 VSS: 2 VSS: rdata_o[8] 3680 2 BUFX2 $T=596160 121440 0 0 $X=595980 $Y=121175
X25971 VSS: 2 VSS: 4254 wdata_i[29] 1641 1949 4253 2 AOI22X2_HS $T=605360 129720 1 180 $X=599660 $Y=129455
X25981 VSS: 2 VSS: 4253 4255 2 CLKBUFX2 $T=600300 138000 0 0 $X=600120 $Y=137735
X25989 VSS: 2 VSS: 4256 1525 wdata_i[26] 2 CLKAND2X2 $T=603520 146280 1 0 $X=603340 $Y=141835
X25998 VSS: 2 VSS: 3498 4177 2 CLKBUFX8 $T=601680 502320 0 0 $X=601500 $Y=502055
X26000 VSS: 2 VSS: 3855 4219 2 BUFX16_HS $T=594780 510600 1 0 $X=594600 $Y=506155
X26002 VSS: 2 VSS: 2321 4259 2 CLKBUFX8 $T=603520 510600 1 180 $X=598280 $Y=510335
X26008 VSS: 2 VSS: 4064 4260 2 BUFX16_HS $T=603520 518880 1 180 $X=593220 $Y=518615
X26011 VSS: 2 VSS: 3761 4261 2 CLKBUFX4 $T=596620 527160 0 180 $X=593680 $Y=522715
X26012 VSS: 2 VSS: 4184 4260 2 BUFX8_HS $T=602140 527160 0 180 $X=596440 $Y=522715
X26017 VSS: 2 VSS: 4219 4064 4224 2 NOR2X4_HS $T=596620 527160 0 0 $X=596440 $Y=526895
X26028 VSS: 2 VSS: 960 4262 2 BUFX16_HS $T=607660 535440 1 180 $X=597360 $Y=535175
X26031 VSS: 2 VSS: 3728 4262 2 BUFX8_HS $T=604440 543720 0 180 $X=598740 $Y=539275
X26038 VSS: 2 VSS: 4257 4300 2 BUFX2_HS $T=609040 543720 1 180 $X=606100 $Y=543455
X26042 VSS: 2 VSS: 4225 4064 4263 2 NOR2X4_HS $T=602140 552000 1 0 $X=601960 $Y=547555
X26045 VSS: 2 VSS: 4262 4068 4263 2 NOR2X4_HS $T=603980 552000 1 180 $X=598740 $Y=551735
X26050 VSS: 2 VSS: 4264 4184 4224 2 NOR2X2_HS $T=596160 560280 1 0 $X=595980 $Y=555835
X26055 VSS: 2 VSS: 3541 4264 2 BUFX16_HS $T=598460 560280 0 0 $X=598280 $Y=560015
X26063 VSS: 2 VSS: 4159 4225 2 BUFX4_HS $T=596620 568560 0 0 $X=596440 $Y=568295
X26072 VSS: 2 VSS: 4265 2995 4267 4302 4188 2 AOI22X2_HS $T=610880 576840 0 180 $X=605180 $Y=572395
X26076 VSS: 2 VSS: 4303 7810 2746 3498 2 DFFX1_HS $T=601220 576840 0 0 $X=601040 $Y=576575
X26081 VSS: 2 VSS: 4266 3862 2 CLKBUFX4 $T=601220 585120 0 180 $X=598280 $Y=580675
X26086 VSS: 2 VSS: 4267 7183 3904 4266 2 DFFX4_HS $T=597080 585120 0 0 $X=596900 $Y=584855
X26089 VSS: 2 VSS: 4031 7811 816 4266 2 DFFX1_HS $T=598000 593400 1 0 $X=597820 $Y=588955
X26093 VSS: 2 VSS: 4305 7812 2696 3498 2 DFFX1_HS $T=601220 593400 0 0 $X=601040 $Y=593135
X26102 VSS: 2 VSS: 4268 3761 2 CLKBUFX2 $T=593400 601680 0 0 $X=593220 $Y=601415
X26107 VSS: 2 VSS: 4307 7813 2696 4268 2 DFFX1_HS $T=605820 601680 0 0 $X=605640 $Y=601415
X26116 VSS: 2 VSS: 4232 7184 3904 3459 2 DFFX4_HS $T=606280 609960 0 0 $X=606100 $Y=609695
X26125 VSS: 2 VSS: 4236 7185 3904 4268 2 DFFX4_HS $T=603060 618240 0 0 $X=602880 $Y=617975
X26144 VSS: 2 VSS: 4269 4310 4265 2 AND2X2_HS $T=609500 634800 1 180 $X=606100 $Y=634535
X26172 VSS: 2 VSS: 4239 4272 4192 2 NOR2X2_HS $T=609960 22080 1 180 $X=606560 $Y=21815
X26182 VSS: 2 VSS: 4271 4273 4274 2 NOR2X2_HS $T=614560 30360 0 180 $X=611160 $Y=25915
X26214 VSS: 2 VSS: 4278 4040 4277 2 NOR2X2_HS $T=613640 46920 1 0 $X=613460 $Y=42475
X26232 VSS: 2 VSS: 4322 4278 4321 2 NAND2X2_HS $T=621920 55200 1 0 $X=621740 $Y=50755
X26238 VSS: 2 VSS: 4199 4280 3037 3042 4281 2 AOI22X1 $T=608120 55200 0 0 $X=607940 $Y=54935
X26249 VSS: 2 VSS: 4274 4248 4282 4283 4171 2 NAND4X2_HS $T=611800 63480 1 0 $X=611620 $Y=59035
X26256 VSS: 2 VSS: 1695 3037 2 CLKBUFX4 $T=607660 63480 0 0 $X=607480 $Y=63215
X26282 VSS: 2 VSS: 4245 4285 3045 3238 4286 2 AOI22X1 $T=622840 80040 0 180 $X=619900 $Y=75595
X26287 VSS: 2 VSS: 4284 3979 2 CLKBUFX2 $T=609500 80040 1 180 $X=607020 $Y=79775
X26308 VSS: 2 VSS: 4287 3741 4286 4288 3747 2 AOI22X2_HS $T=617780 88320 0 0 $X=617600 $Y=88055
X26336 VSS: 2 VSS: 4249 4288 4250 2568 2 AOI21X1 $T=609500 104880 1 180 $X=607020 $Y=104615
X26344 VSS: 2 VSS: 4250 4289 3748 2 NAND2X1 $T=608580 113160 0 180 $X=606560 $Y=108715
X26370 VSS: 2 VSS: 4326 7814 1843 3744 2 DFFX1_HS $T=616400 121440 0 0 $X=616220 $Y=121175
X26389 VSS: 2 VSS: 4290 4254 2 CLKINVX4 $T=607660 138000 1 0 $X=607480 $Y=133555
X26402 VSS: 2 VSS: 4293 4291 1949 1641 wdata_i[30] 2 AOI22X1 $T=620080 138000 0 0 $X=619900 $Y=137735
X26410 VSS: 2 VSS: 4294 4293 2 INVX2 $T=621000 146280 1 0 $X=620820 $Y=141835
X26417 VSS: 2 VSS: 4295 3062 1525 1949 3159 2 AOI22X2_HS $T=618700 146280 1 180 $X=613000 $Y=146015
X26564 VSS: 2 VSS: 4255 2708 2 CLKBUFX2 $T=609040 502320 1 180 $X=606560 $Y=502055
X26570 VSS: 2 VSS: 4016 4337 2 CLKBUFX8 $T=627440 502320 1 180 $X=622200 $Y=502055
X26574 VSS: 2 VSS: 2005 4297 2 CLKBUFX8 $T=613640 510600 0 180 $X=608400 $Y=506155
X26575 VSS: 2 VSS: 3725 4298 2 BUFX16_HS $T=623760 510600 0 180 $X=613460 $Y=506155
X26582 VSS: 2 VSS: 4298 4147 2 BUFX4_HS $T=620080 510600 1 180 $X=616220 $Y=510335
X26589 VSS: 2 VSS: 4296 4147 2 BUFX16_HS $T=622380 518880 0 180 $X=612080 $Y=514435
X26613 VSS: 2 VSS: 4299 4152 2 INVX4 $T=614560 527160 0 0 $X=614380 $Y=526895
X26620 VSS: 2 VSS: 4220 4150 4153 4299 2 NAND3X4_HS $T=611800 535440 1 0 $X=611620 $Y=530995
X26653 VSS: 2 VSS: 4155 4344 4222 2 NOR2X4_HS $T=623760 552000 0 180 $X=618520 $Y=547555
X26660 VSS: 2 VSS: 3783 4300 2 BUFX16_HS $T=610880 552000 0 0 $X=610700 $Y=551735
X26669 VSS: 2 VSS: 3497 4300 2 BUFX16_HS $T=615480 560280 1 0 $X=615300 $Y=555835
X26682 VSS: 2 VSS: 4301 7815 2696 3538 2 DFFX1_HS $T=613180 568560 1 0 $X=613000 $Y=564115
X26704 VSS: 2 VSS: 4304 7816 1926 4266 2 DFFX1_HS $T=610420 576840 0 0 $X=610240 $Y=576575
X26739 VSS: 2 VSS: 4306 7817 2696 3459 2 DFFX1_HS $T=607660 601680 1 0 $X=607480 $Y=597235
X26753 VSS: 2 VSS: 4308 7818 1926 3459 2 DFFX1_HS $T=613640 609960 1 0 $X=613460 $Y=605515
X26789 VSS: 2 VSS: 4310 4191 4309 4353 4159 2 AOI22X2_HS $T=623760 626520 1 180 $X=618060 $Y=626255
X26827 VSS: 2 VSS: 3799 4312 2 BUFX16_HS $T=637100 13800 1 180 $X=626800 $Y=13535
X26831 VSS: 2 VSS: 4316 3728 4315 4314 4313 2 AOI22X2_HS $T=627900 22080 1 0 $X=627720 $Y=17635
X26837 VSS: 2 VSS: 4244 4317 3024 3226 4314 2 AOI22X1 $T=630660 22080 0 0 $X=630480 $Y=21815
X26843 VSS: 2 VSS: 2012 3226 2 CLKBUFX4 $T=633420 30360 1 0 $X=633240 $Y=25915
X26848 VSS: 2 VSS: 4318 3725 4317 4112 3810 2 AOI22X2_HS $T=634340 30360 0 0 $X=634160 $Y=30095
X26850 VSS: 2 VSS: 4319 4320 4287 4318 4316 2 NAND4X2_HS $T=625140 38640 1 0 $X=624960 $Y=34195
X26857 VSS: 2 VSS: 4320 3737 4197 4281 4175 2 AOI22X2 $T=638020 38640 1 180 $X=633240 $Y=38375
X26864 VSS: 2 VSS: 4321 4319 4279 2 NOR2X2_HS $T=626060 46920 1 180 $X=622660 $Y=46655
X26874 VSS: 2 VSS: 2439 4322 2 BUFX16_HS $T=626520 55200 0 0 $X=626340 $Y=54935
X26881 VSS: 2 VSS: 1716 3042 2 CLKBUFX4 $T=625600 63480 0 0 $X=625420 $Y=63215
X26902 VSS: 2 VSS: 3414 4323 2 BUFX16_HS $T=639400 80040 1 180 $X=629100 $Y=79775
X26903 VSS: 2 VSS: 2007 3238 2 CLKBUFX4 $T=624220 88320 1 0 $X=624040 $Y=83875
X26914 VSS: 2 VSS: rdata_o[9] 4325 4249 4324 4275 2 NAND4X2 $T=628360 96600 0 180 $X=623580 $Y=92155
X26921 VSS: 2 VSS: 4286 7819 1843 3942 2 DFFX1_HS $T=635720 96600 0 0 $X=635540 $Y=96335
X26927 VSS: 2 VSS: 4325 4204 2991 2992 4326 2 AOI22X1 $T=624680 104880 0 0 $X=624500 $Y=104615
X26934 VSS: 2 VSS: 4289 4328 2312 2311 4327 2 AOI22X1 $T=628820 113160 0 180 $X=625880 $Y=108715
X26940 VSS: 2 VSS: 4115 4329 2 CLKBUFX4 $T=626980 113160 1 180 $X=624040 $Y=112895
X26945 VSS: 2 VSS: 4328 7820 1843 3522 2 DFFX1_HS $T=637100 113160 0 0 $X=636920 $Y=112895
X26947 VSS: 2 VSS: 4327 7821 1843 3565 2 DFFX1_HS $T=623760 121440 1 0 $X=623580 $Y=116995
X26959 VSS: 2 VSS: 4331 4330 2 INVX8_HS $T=639400 129720 0 180 $X=634160 $Y=125275
X26964 VSS: 2 VSS: 4330 1822 2139 2 NAND2X4_HS $T=633880 129720 0 0 $X=633700 $Y=129455
X26967 VSS: 2 VSS: 4291 2629 2 CLKBUFX2 $T=627900 138000 0 180 $X=625420 $Y=133555
X26980 VSS: 2 VSS: 4333 4332 2 INVX2 $T=633880 146280 0 180 $X=632320 $Y=141835
X26985 VSS: 2 VSS: 4334 1525 wdata_i[30] 2 CLKAND2X2 $T=633420 146280 0 0 $X=633240 $Y=146015
X26986 VSS: 2 VSS: 4335 1525 wdata_i[27] 2 CLKAND2X2 $T=635720 146280 0 0 $X=635540 $Y=146015
X26988 VSS: 2 VSS: 4336 3830 2 INVX16_HS $T=635720 502320 1 180 $X=627260 $Y=502055
X26992 VSS: 2 VSS: 3743 4026 2 CLKBUFX8 $T=638940 502320 0 0 $X=638760 $Y=502055
X26997 VSS: 2 VSS: 4338 3830 2 INVX16_HS $T=633880 510600 1 0 $X=633700 $Y=506155
X27005 VSS: 2 VSS: 3459 4329 2 CLKBUFX8 $T=635720 518880 0 180 $X=630480 $Y=514435
X27007 VSS: 2 VSS: 4340 4339 2 INVX4 $T=639860 518880 0 180 $X=637380 $Y=514435
X27012 VSS: 2 VSS: 4260 4341 4340 2 NAND2X4_HS $T=635260 518880 0 0 $X=635080 $Y=518615
X27014 VSS: 2 VSS: 4342 4341 2 INVX4_HS $T=623760 527160 1 0 $X=623580 $Y=522715
X27030 VSS: 2 VSS: 4065 4342 4343 2 NAND2X4_HS $T=630200 535440 0 0 $X=630020 $Y=535175
X27035 VSS: 2 VSS: 4222 4342 4343 2 NAND2X4_HS $T=625600 543720 1 0 $X=625420 $Y=539275
X27040 VSS: 2 VSS: 4300 4263 4222 2 NOR2X4_HS $T=624680 543720 0 0 $X=624500 $Y=543455
X27050 VSS: 2 VSS: 4345 7186 2945 3455 2 DFFX4_HS $T=625600 552000 0 0 $X=625420 $Y=551735
X27057 VSS: 2 VSS: 4309 7187 3904 3455 2 DFFX4_HS $T=624220 560280 0 0 $X=624040 $Y=560015
X27064 VSS: 2 VSS: 4097 7822 816 4346 2 DFFX1_HS $T=638480 568560 1 0 $X=638300 $Y=564115
X27069 VSS: 2 VSS: 4351 7188 2945 4346 2 DFFX4_HS $T=637560 568560 0 0 $X=637380 $Y=568295
X27077 VSS: 2 VSS: 4347 7189 2945 4266 2 DFFX4_HS $T=629280 576840 0 0 $X=629100 $Y=576575
X27081 VSS: 2 VSS: 4377 7823 2746 4266 2 DFFX1_HS $T=634340 585120 1 0 $X=634160 $Y=580675
X27086 VSS: 2 VSS: 4380 7824 2696 4266 2 DFFX1_HS $T=632960 585120 0 0 $X=632780 $Y=584855
X27090 VSS: 2 VSS: 4348 7825 2746 3459 2 DFFX1_HS $T=631580 593400 1 0 $X=631400 $Y=588955
X27094 VSS: 2 VSS: 4381 7826 2746 3549 2 DFFX1_HS $T=633420 593400 0 0 $X=633240 $Y=593135
X27099 VSS: 2 VSS: 4382 7827 2696 3549 2 DFFX1_HS $T=633880 601680 1 0 $X=633700 $Y=597235
X27113 VSS: 2 VSS: 4384 7828 1926 3549 2 DFFX1_HS $T=635260 609960 0 0 $X=635080 $Y=609695
X27116 VSS: 2 VSS: 4349 7190 2945 3459 2 DFFX4_HS $T=626980 618240 1 0 $X=626800 $Y=613795
X27120 VSS: 2 VSS: 4350 7191 2945 4268 2 DFFX4_HS $T=629740 618240 0 0 $X=629560 $Y=617975
X27126 VSS: 2 VSS: 4352 4159 4351 4345 2978 2 AOI22X2_HS $T=634340 626520 1 0 $X=634160 $Y=622075
X27136 VSS: 2 VSS: 4385 3403 4350 4190 4161 2 AOI22X2_HS $T=642620 634800 0 180 $X=636920 $Y=630355
X27142 VSS: 2 VSS: 4387 4045 4228 4349 4386 2 AOI22X2_HS $T=638020 634800 0 0 $X=637840 $Y=634535
X27148 VSS: 2 VSS: 4388 4387 4385 4379 4352 2 NAND4X4_HS $T=645380 643080 0 180 $X=636460 $Y=638635
X27162 VSS: 2 VSS: 4317 7829 1843 3970 2 DFFX1_HS $T=653200 13800 0 0 $X=653020 $Y=13535
X27175 VSS: 2 VSS: 4273 4389 4354 4390 4355 2 NAND4X1_HS $T=656880 22080 1 180 $X=653480 $Y=21815
X27201 VSS: 2 VSS: 4272 4357 4359 4358 4356 2 NAND4X2_HS $T=642620 46920 1 0 $X=642440 $Y=42475
X27218 VSS: 2 VSS: 4277 4363 4361 4360 4362 2 NAND4X2_HS $T=649980 55200 1 0 $X=649800 $Y=50755
X27227 VSS: 2 VSS: 4281 7830 1843 3598 2 DFFX1_HS $T=652280 55200 0 0 $X=652100 $Y=54935
X27233 VSS: 2 VSS: 4361 3476 4078 4328 3440 2 AOI22X2 $T=649980 63480 1 0 $X=649800 $Y=59035
X27243 VSS: 2 VSS: 4357 4393 4078 4328 3432 2 AOI22X2 $T=657340 63480 1 180 $X=652560 $Y=63215
X27245 VSS: 2 VSS: 4358 4365 4285 4364 3513 2 AOI22X2_HS $T=651820 71760 0 180 $X=646120 $Y=67315
X27253 VSS: 2 VSS: 4363 4207 4285 4364 4366 2 AOI22X2 $T=644460 71760 0 0 $X=644280 $Y=71495
X27260 VSS: 2 VSS: 4355 4367 4288 4286 3774 2 AOI22X2 $T=649980 80040 1 0 $X=649800 $Y=75595
X27272 VSS: 2 VSS: 4280 7831 1843 136 2 DFFX1_HS $T=644000 88320 1 0 $X=643820 $Y=83875
X27281 VSS: 2 VSS: 4360 3438 4326 4327 4140 2 AOI22X1_HS $T=655960 88320 1 180 $X=652560 $Y=88055
X27287 VSS: 2 VSS: 4285 7832 1843 3743 2 DFFX1_HS $T=652740 96600 1 0 $X=652560 $Y=92155
X27295 VSS: 2 VSS: 4359 3247 4327 4326 918 2 AOI22X2 $T=640320 104880 1 0 $X=640140 $Y=100435
X27306 VSS: 2 VSS: 4396 4395 2 INVX16_HS $T=660560 104880 1 180 $X=652100 $Y=104615
X27312 VSS: 2 VSS: 4395 1822 2648 2 NAND2X4_HS $T=653660 113160 1 0 $X=653480 $Y=108715
X27330 VSS: 2 VSS: 4288 7833 1843 3896 2 DFFX1_HS $T=645380 121440 0 0 $X=645200 $Y=121175
X27347 VSS: 2 VSS: 4368 2624 2 CLKBUFX2 $T=646300 138000 0 180 $X=643820 $Y=133555
X27355 VSS: 2 VSS: 4332 4368 1949 1641 wdata_i[31] 2 AOI22X1 $T=642160 138000 0 0 $X=641980 $Y=137735
X27361 VSS: 2 VSS: 4370 1525 wdata_i[31] 2 CLKAND2X2 $T=648600 146280 1 0 $X=648420 $Y=141835
X27372 VSS: 2 VSS: 4399 4400 1949 1525 3102 2 AOI22X1 $T=655040 146280 0 0 $X=654860 $Y=146015
X27446 VSS: 2 VSS: 4372 1364 4371 2 AND2X1_HS $T=652740 510600 0 0 $X=652560 $Y=510335
X27447 VSS: 2 VSS: 4339 4372 2 BUFX8_HS $T=655500 510600 0 0 $X=655320 $Y=510335
X27463 VSS: 2 VSS: 3918 4220 4182 2 NOR2X4_HS $T=647220 527160 1 0 $X=647040 $Y=522715
X27464 VSS: 2 VSS: 3538 4403 2 CLKBUFX8 $T=657340 527160 0 180 $X=652100 $Y=522715
X27472 VSS: 2 VSS: 4373 4339 4341 2 NAND2X4_HS $T=654120 527160 1 180 $X=648880 $Y=526895
X27477 VSS: 2 VSS: 4068 4373 2 BUFX16_HS $T=645840 535440 1 0 $X=645660 $Y=530995
X27497 VSS: 2 VSS: 4374 4300 2 BUFX16_HS $T=642160 552000 1 0 $X=641980 $Y=547555
X27506 VSS: 2 VSS: 4407 7834 2746 3538 2 DFFX1_HS $T=650900 552000 0 0 $X=650720 $Y=551735
X27507 VSS: 2 VSS: 4353 7192 3904 4346 2 DFFX4_HS $T=640320 560280 1 0 $X=640140 $Y=555835
X27518 VSS: 2 VSS: 4375 4161 4303 4376 3403 2 AOI22X1 $T=657340 560280 1 180 $X=654400 $Y=560015
X27530 VSS: 2 VSS: 4379 2995 4347 4378 4188 2 AOI22X2_HS $T=650440 576840 0 180 $X=644740 $Y=572395
X27573 VSS: 2 VSS: 4376 7835 2746 4268 2 DFFX1_HS $T=643080 601680 0 0 $X=642900 $Y=601415
X27576 VSS: 2 VSS: 4383 7836 1926 4268 2 DFFX1_HS $T=643080 609960 1 0 $X=642900 $Y=605515
X27597 VSS: 2 VSS: 4416 7837 1926 3499 2 DFFX1_HS $T=649980 618240 0 0 $X=649800 $Y=617975
X27633 VSS: 2 VSS: 4313 3723 2 BUFX16_HS $T=668380 13800 1 0 $X=668200 $Y=9355
X27652 VSS: 2 VSS: 4389 4391 4112 4317 3721 2 AOI22X1_HS $T=655960 30360 1 0 $X=655780 $Y=25915
X27665 VSS: 2 VSS: 4354 4281 4197 4392 1412 2 AOI22X1 $T=658260 38640 1 0 $X=658080 $Y=34195
X27675 VSS: 2 VSS: 4197 7838 1843 3972 2 DFFX1_HS $T=670680 38640 0 0 $X=670500 $Y=38375
X27742 VSS: 2 VSS: 4324 4420 2785 2796 4364 2 AOI22X1 $T=670680 88320 1 0 $X=670500 $Y=83875
X27761 VSS: 2 VSS: 4420 7839 1843 4116 2 DFFX1_HS $T=670220 96600 0 0 $X=670040 $Y=96335
X27769 VSS: 2 VSS: 4080 4394 2 CLKINVX1_HS $T=670680 104880 0 180 $X=667740 $Y=100435
X27794 VSS: 2 VSS: 3720 4397 2 BUFX16_HS $T=669300 121440 1 0 $X=669120 $Y=116995
X27818 VSS: 2 VSS: 4323 3540 2 BUFX16_HS $T=681260 138000 0 180 $X=670960 $Y=133555
X27822 VSS: 2 VSS: 4398 1525 wdata_i[28] 2 CLKAND2X2 $T=663320 138000 0 0 $X=663140 $Y=137735
X27832 VSS: 2 VSS: 1687 4426 2 CLKBUFX8_HS $T=673900 146280 0 180 $X=664980 $Y=141835
X27838 VSS: 2 VSS: 3089 4430 2 BUFX2 $T=673440 146280 1 180 $X=670960 $Y=146015
X27915 VSS: 2 VSS: 4026 4401 2 CLKBUFX8 $T=665160 502320 1 180 $X=659920 $Y=502055
X27922 VSS: 2 VSS: 4371 1641 4400 2 AND2X1_HS $T=659180 510600 0 180 $X=656240 $Y=506155
X27935 VSS: 2 VSS: 4402 4260 2 CLKBUFX2 $T=657800 518880 1 0 $X=657620 $Y=514435
X27944 VSS: 2 VSS: 3723 3918 2 BUFX8_HS $T=670680 518880 0 0 $X=670500 $Y=518615
X27967 VSS: 2 VSS: 4404 4152 2 INVX4 $T=665620 535440 1 180 $X=663140 $Y=535175
X27976 VSS: 2 VSS: 4344 4404 4405 4153 2 NAND3X2_HS $T=663780 543720 0 180 $X=659000 $Y=539275
X27982 VSS: 2 VSS: 4093 4405 4153 4404 2 NAND3X4_HS $T=665620 543720 1 180 $X=658540 $Y=543455
X27990 VSS: 2 VSS: 3455 4406 2 CLKBUFX8 $T=663780 552000 0 180 $X=658540 $Y=547555
X27994 VSS: 2 VSS: 4405 4150 2 INVX8_HS $T=669760 552000 1 0 $X=669580 $Y=547555
X28007 VSS: 2 VSS: 3499 4337 2 CLKBUFX8 $T=659180 560280 0 0 $X=659000 $Y=560015
X28018 VSS: 2 VSS: 4436 4437 4435 4375 4408 2 NAND4X2_HS $T=675740 568560 0 180 $X=670040 $Y=564115
X28033 VSS: 2 VSS: 4409 4163 2 BUFX2_HS $T=658260 576840 0 0 $X=658080 $Y=576575
X28044 VSS: 2 VSS: 4411 2995 4304 4410 4188 2 AOI22X2 $T=667000 585120 1 0 $X=666820 $Y=580675
X28048 VSS: 2 VSS: 4412 4161 4305 4307 3403 2 AOI22X1 $T=658260 585120 0 0 $X=658080 $Y=584855
X28060 VSS: 2 VSS: 4413 7840 2746 3499 2 DFFX1_HS $T=657800 593400 0 0 $X=657620 $Y=593135
X28067 VSS: 2 VSS: 4414 7841 2696 3499 2 DFFX1_HS $T=658260 601680 1 0 $X=658080 $Y=597235
X28085 VSS: 2 VSS: 4446 7842 2746 3548 2 DFFX1_HS $T=666540 609960 0 0 $X=666360 $Y=609695
X28093 VSS: 2 VSS: 4415 4045 4227 4308 4409 2 AOI22X2 $T=663780 618240 1 0 $X=663600 $Y=613795
X28098 VSS: 2 VSS: 4417 7843 2696 3548 2 DFFX1_HS $T=663780 618240 0 0 $X=663600 $Y=617975
X28105 VSS: 2 VSS: 4450 7844 1926 3548 2 DFFX1_HS $T=667460 626520 1 0 $X=667280 $Y=622075
X28107 VSS: 2 VSS: 4418 4161 4229 4383 3403 2 AOI22X2 $T=660560 626520 0 0 $X=660380 $Y=626255
X28146 VSS: 2 VSS: 4390 4312 4315 4314 3801 2 AOI22X2 $T=679420 22080 0 180 $X=674640 $Y=17635
X28155 VSS: 2 VSS: 4314 7845 1843 3971 2 DFFX1_HS $T=676660 22080 0 0 $X=676480 $Y=21815
X28162 VSS: 2 VSS: 4315 7846 1843 4010 2 DFFX1_HS $T=686320 30360 1 0 $X=686140 $Y=25915
X28168 VSS: 2 VSS: 4195 4419 2317 2343 4315 2 AOI22X1 $T=677120 30360 1 180 $X=674180 $Y=30095
X28187 VSS: 2 VSS: 4276 3870 3869 4420 4419 2 AOI22X2_HS $T=680340 46920 1 0 $X=680160 $Y=42475
X28202 VSS: 2 VSS: 4362 3424 4196 4280 4323 2 AOI22X2_HS $T=684480 55200 1 0 $X=684300 $Y=50755
X28209 VSS: 2 VSS: 4419 7847 1843 4136 2 DFFX1_HS $T=680340 55200 0 0 $X=680160 $Y=54935
X28213 VSS: 2 VSS: 4283 4422 4420 4419 4421 2 AOI22X1_HS $T=682180 63480 1 0 $X=682000 $Y=59035
X28228 VSS: 2 VSS: 3379 4454 2 BUFX8 $T=691380 71760 0 180 $X=686140 $Y=67315
X28235 VSS: 2 VSS: 3772 4423 2 BUFX8_HS $T=686780 71760 1 180 $X=681080 $Y=71495
X28240 VSS: 2 VSS: 4421 4394 2 CLKINVX2 $T=685400 80040 0 180 $X=683840 $Y=75595
X28245 VSS: 2 VSS: 4424 7848 2677 3516 2 DFFX1_HS $T=672060 80040 0 0 $X=671880 $Y=79775
X28249 VSS: 2 VSS: 3516 4457 2 CLKBUFX8 $T=691380 80040 1 180 $X=686140 $Y=79775
X28262 VSS: 2 VSS: 4458 7849 2677 3743 2 DFFX1_HS $T=685400 88320 0 0 $X=685220 $Y=88055
X28268 VSS: 2 VSS: 4459 7850 2627 3743 2 DFFX1_HS $T=685400 96600 1 0 $X=685220 $Y=92155
X28273 VSS: 2 VSS: 4137 4425 2 CLKBUFX8 $T=681260 96600 0 0 $X=681080 $Y=96335
X28286 VSS: 2 VSS: 4364 7851 1843 3676 2 DFFX1_HS $T=685400 104880 0 0 $X=685220 $Y=104615
X28307 VSS: 2 VSS: 4397 4426 2 BUFX4_HS $T=677580 121440 1 180 $X=673720 $Y=121175
X28312 VSS: 2 VSS: 4427 1822 2643 2 NAND2X4_HS $T=674360 129720 1 0 $X=674180 $Y=125275
X28322 VSS: 2 VSS: 3196 4394 2 INVX16_HS $T=673440 129720 0 0 $X=673260 $Y=129455
X28333 VSS: 2 VSS: 4428 1525 wdata_i[29] 2 CLKAND2X2 $T=682180 138000 0 0 $X=682000 $Y=137735
X28341 VSS: 2 VSS: 4464 4399 2 BUFX2 $T=687700 146280 1 0 $X=687520 $Y=141835
X28345 VSS: 2 VSS: 4177 4429 2 CLKBUFX8 $T=678500 146280 1 180 $X=673260 $Y=146015
X28423 VSS: 2 VSS: 4425 4261 2 CLKBUFX4 $T=680800 502320 0 0 $X=680620 $Y=502055
X28425 VSS: 2 VSS: 4431 813 2913 2 AND2X1_HS $T=687240 502320 1 180 $X=684300 $Y=502055
X28431 VSS: 2 VSS: 4466 4431 2 BUFX16_HS $T=682640 510600 1 0 $X=682460 $Y=506155
X28440 VSS: 2 VSS: 4467 4341 4339 2 OR2X1_HS $T=685860 510600 0 0 $X=685680 $Y=510335
X28458 VSS: 2 VSS: 4343 4339 2 BUFX8_HS $T=686320 527160 1 0 $X=686140 $Y=522715
X28468 VSS: 2 VSS: 4163 4344 4182 2 NOR2X4_HS $T=693220 527160 1 180 $X=687980 $Y=526895
X28472 VSS: 2 VSS: 4046 4163 2 BUFX16_HS $T=680340 535440 1 0 $X=680160 $Y=530995
X28480 VSS: 2 VSS: 4386 4163 2 BUFX8_HS $T=687700 535440 0 0 $X=687520 $Y=535175
X28497 VSS: 2 VSS: 4432 7852 2746 4346 2 DFFX1_HS $T=680800 552000 1 0 $X=680620 $Y=547555
X28506 VSS: 2 VSS: 4441 7853 2696 4346 2 DFFX1_HS $T=685400 552000 0 0 $X=685220 $Y=551735
X28507 VSS: 2 VSS: 4408 4159 4432 4433 2978 2 AOI22X1_HS $T=672060 560280 1 0 $X=671880 $Y=555835
X28517 VSS: 2 VSS: 4435 4188 4434 4377 2995 2 AOI22X1_HS $T=679880 560280 1 180 $X=676480 $Y=560015
X28534 VSS: 2 VSS: 4437 4409 4348 4407 4045 2 AOI22X1 $T=678960 576840 0 180 $X=676020 $Y=572395
X28544 VSS: 2 VSS: 4439 4188 4438 4380 2995 2 AOI22X1 $T=682640 576840 1 180 $X=679700 $Y=576575
X28558 VSS: 2 VSS: 4442 4159 4441 4440 4191 2 AOI22X1 $T=681260 585120 1 180 $X=678320 $Y=584855
X28564 VSS: 2 VSS: 4443 4444 4442 4412 4439 2 NAND4X2_HS $T=682640 593400 0 180 $X=676940 $Y=588955
X28573 VSS: 2 VSS: 4444 4445 4306 4301 4045 2 AOI22X1 $T=680800 593400 0 0 $X=680620 $Y=593135
X28580 VSS: 2 VSS: 4475 7854 2696 3547 2 DFFX1_HS $T=684480 601680 1 0 $X=684300 $Y=597235
X28584 VSS: 2 VSS: 4445 4163 2 BUFX2 $T=674360 601680 0 0 $X=674180 $Y=601415
X28593 VSS: 2 VSS: 4447 3401 4383 4229 3453 2 AOI22X2 $T=683100 609960 1 0 $X=682920 $Y=605515
X28614 VSS: 2 VSS: 4449 4416 3028 3029 4229 2 AOI22X1 $T=684020 618240 0 0 $X=683840 $Y=617975
X28628 VSS: 2 VSS: 4478 7855 1926 3547 2 DFFX1_HS $T=687700 626520 0 0 $X=687520 $Y=626255
X28633 VSS: 2 VSS: 4452 4191 4451 4448 4159 2 AOI22X2 $T=683560 634800 1 0 $X=683380 $Y=630355
X28641 VSS: 2 VSS: 4479 4418 4452 4415 4411 2 NAND4X4_HS $T=690000 634800 1 180 $X=681080 $Y=634535
X28657 VSS: 2 VSS: 4453 3728 2 BUFX16_HS $T=690920 13800 0 0 $X=690740 $Y=13535
X28680 VSS: 2 VSS: 4455 4454 2 CLKBUFX2_HS $T=701040 30360 1 180 $X=697640 $Y=30095
X28685 VSS: 2 VSS: 4356 4455 4280 4196 4456 2 AOI22X2_HS $T=690460 38640 1 0 $X=690280 $Y=34195
X28750 VSS: 2 VSS: 4499 1822 2626 2 NAND2X4_HS $T=702880 80040 1 0 $X=702700 $Y=75595
X28762 VSS: 2 VSS: 3886 4500 2 BUFX8_HS $T=707020 88320 0 180 $X=701320 $Y=83875
X28777 VSS: 2 VSS: 4461 4460 2 INVX16_HS $T=705180 96600 1 180 $X=696720 $Y=96335
X28785 VSS: 2 VSS: 4460 1822 2125 2 NAND2X4_HS $T=697820 104880 1 0 $X=697640 $Y=100435
X28795 VSS: 2 VSS: 4463 4462 2 INVX16_HS $T=693220 113160 1 0 $X=693040 $Y=108715
X28799 VSS: 2 VSS: 4462 1822 1798 2 NAND2X4_HS $T=695060 113160 1 180 $X=689820 $Y=112895
X28815 VSS: 2 VSS: 4503 7856 2627 3896 2 DFFX1_HS $T=699200 121440 0 0 $X=699020 $Y=121175
X28849 VSS: 2 VSS: 4465 410 wdata_i[22] 2 CLKAND2X2 $T=689080 146280 0 0 $X=688900 $Y=146015
X28939 VSS: 2 VSS: 4182 4467 2 BUFX8_HS $T=688620 510600 0 0 $X=688440 $Y=510335
X28951 VSS: 2 VSS: 3990 4182 4263 2 NOR2X4_HS $T=689080 518880 0 0 $X=688900 $Y=518615
X28981 VSS: 2 VSS: 4263 4152 4405 4468 2 NAND3X4_HS $T=688620 543720 1 0 $X=688440 $Y=539275
X28987 VSS: 2 VSS: 4302 7193 3904 4469 2 DFFX4_HS $T=698740 543720 0 0 $X=698560 $Y=543455
X28993 VSS: 2 VSS: 4346 4128 2 CLKBUFX2 $T=691380 552000 1 0 $X=691200 $Y=547555
X28997 VSS: 2 VSS: 3996 7857 816 4469 2 DFFX1_HS $T=700120 552000 1 0 $X=699940 $Y=547555
X29020 VSS: 2 VSS: 4448 7858 1926 4346 2 DFFX1_HS $T=704260 568560 1 0 $X=704080 $Y=564115
X29024 VSS: 2 VSS: 4470 4471 4441 4440 3327 2 AOI22X2_HS $T=706100 568560 1 180 $X=700400 $Y=568295
X29032 VSS: 2 VSS: 4472 4432 3039 3198 4376 2 AOI22X1 $T=698740 576840 1 0 $X=698560 $Y=572395
X29039 VSS: 2 VSS: 4471 3980 2 CLKBUFX2 $T=701960 576840 0 0 $X=701780 $Y=576575
X29044 VSS: 2 VSS: 4473 7859 2746 3547 2 DFFX1_HS $T=688620 585120 1 0 $X=688440 $Y=580675
X29051 VSS: 2 VSS: 4474 4441 3039 3198 4307 2 AOI22X1 $T=698740 585120 0 0 $X=698560 $Y=584855
X29073 VSS: 2 VSS: 4476 4448 3039 3198 4383 2 AOI22X1 $T=697820 601680 0 0 $X=697640 $Y=601415
X29093 VSS: 2 VSS: 4477 4351 3039 3198 4350 2 AOI22X1 $T=691380 618240 1 0 $X=691200 $Y=613795
X29128 VSS: 2 VSS: 4480 4162 4190 4350 3401 2 AOI22X2_HS $T=691840 643080 1 0 $X=691660 $Y=638635
X29137 VSS: 2 VSS: 4483 4482 4481 2 NOR2X2_HS $T=715300 13800 1 0 $X=715120 $Y=9355
X29146 VSS: 2 VSS: 4485 4484 4483 2 NAND2X2_HS $T=715760 22080 0 180 $X=712360 $Y=17635
X29150 VSS: 2 VSS: 2495 4485 2 BUFX16_HS $T=708860 22080 0 0 $X=708680 $Y=21815
X29168 VSS: 2 VSS: 4490 4487 4489 4486 4488 2 NAND4X4_HS $T=722200 38640 1 180 $X=713280 $Y=38375
X29171 VSS: 2 VSS: 4482 4491 4493 4492 4494 2 NAND4X2_HS $T=715300 46920 1 0 $X=715120 $Y=42475
X29181 VSS: 2 VSS: 4196 7860 1843 4495 2 DFFX1_HS $T=714840 55200 1 0 $X=714660 $Y=50755
X29185 VSS: 2 VSS: 4489 3476 4497 4496 3440 2 AOI22X2_HS $T=719900 55200 1 180 $X=714200 $Y=54935
X29188 VSS: 2 VSS: 4491 4393 4497 4496 3432 2 AOI22X2 $T=711160 63480 1 0 $X=710980 $Y=59035
X29200 VSS: 2 VSS: 4494 3513 4365 4459 4498 2 AOI22X2 $T=722660 71760 0 180 $X=717880 $Y=67315
X29206 VSS: 2 VSS: 4488 3855 4459 4498 4366 2 AOI22X2_HS $T=718980 71760 0 0 $X=718800 $Y=71495
X29227 VSS: 2 VSS: 3515 4501 2 BUFX16_HS $T=721280 96600 0 180 $X=710980 $Y=92155
X29251 VSS: 2 VSS: 4496 7861 2627 3522 2 DFFX1_HS $T=718980 113160 0 0 $X=718800 $Y=112895
X29254 VSS: 2 VSS: 4502 7862 2677 3896 2 DFFX1_HS $T=706560 121440 1 0 $X=706380 $Y=116995
X29267 VSS: 2 VSS: 4504 4427 2 INVX16_HS $T=707940 129720 0 0 $X=707760 $Y=129455
X29273 VSS: 2 VSS: 3326 4535 2 BUFX16_HS $T=726340 138000 0 180 $X=716040 $Y=133555
X29277 VSS: 2 VSS: 4505 1822 2860 2 NAND2X4_HS $T=709780 138000 0 0 $X=709600 $Y=137735
X29281 VSS: 2 VSS: 4506 1525 2 BUFX2 $T=708400 146280 1 0 $X=708220 $Y=141835
X29288 VSS: 2 VSS: 3874 4507 2 CLKBUFX8 $T=717600 146280 1 180 $X=712360 $Y=146015
X29293 VSS: 2 VSS: 3438 4508 2 BUFX16_HS $T=721740 502320 1 180 $X=711440 $Y=502055
X29295 VSS: 2 VSS: 4508 4510 2 BUFX4_HS $T=711160 510600 1 0 $X=710980 $Y=506155
X29296 VSS: 2 VSS: 4061 4509 2 CLKBUFX8 $T=719900 510600 0 180 $X=714660 $Y=506155
X29302 VSS: 2 VSS: 3572 4510 2 BUFX2_HS $T=717600 510600 1 180 $X=714660 $Y=510335
X29306 VSS: 2 VSS: 3327 4511 2 BUFX16_HS $T=719440 518880 0 180 $X=709140 $Y=514435
X29309 VSS: 2 VSS: 3401 4206 2 BUFX16_HS $T=707020 518880 0 0 $X=706840 $Y=518615
X29318 VSS: 2 VSS: 4513 4511 2 BUFX8_HS $T=720820 527160 1 0 $X=720640 $Y=522715
X29327 VSS: 2 VSS: 4512 4068 4224 2 NOR2X4_HS $T=719900 535440 0 180 $X=714660 $Y=530995
X29332 VSS: 2 VSS: 4224 4514 2 INVX4_HS $T=717140 535440 1 180 $X=713740 $Y=535175
X29340 VSS: 2 VSS: 4514 4515 4468 2 NOR2X2_HS $T=720360 543720 0 180 $X=716960 $Y=539275
X29356 VSS: 2 VSS: 4516 3980 4432 4433 3327 2 AOI22X2 $T=712080 560280 0 180 $X=707300 $Y=555835
X29362 VSS: 2 VSS: 4517 3401 3326 4303 4376 2 AOI22X2_HS $T=713460 560280 1 180 $X=707760 $Y=560015
X29387 VSS: 2 VSS: 4518 4413 3028 3029 4303 2 AOI22X1 $T=713000 585120 1 0 $X=712820 $Y=580675
X29404 VSS: 2 VSS: 4519 3401 4307 4305 4162 2 AOI22X2 $T=710700 593400 0 0 $X=710520 $Y=593135
X29409 VSS: 2 VSS: 4520 4414 3028 3029 4305 2 AOI22X1 $T=710240 601680 1 0 $X=710060 $Y=597235
X29422 VSS: 2 VSS: 4521 4451 4448 3980 4513 2 AOI22X1_HS $T=704720 609960 0 0 $X=704540 $Y=609695
X29429 VSS: 2 VSS: 4522 4353 3039 3198 4236 2 AOI22X1 $T=709780 618240 1 0 $X=709600 $Y=613795
X29435 VSS: 2 VSS: 4524 4353 4309 4513 4523 2 AOI22X2_HS $T=707940 618240 0 0 $X=707760 $Y=617975
X29441 VSS: 2 VSS: 4525 4513 4345 4351 3980 2 AOI22X2_HS $T=708860 626520 1 0 $X=708680 $Y=622075
X29445 VSS: 2 VSS: 4523 3980 2 CLKBUFX2 $T=708860 626520 0 0 $X=708680 $Y=626255
X29497 VSS: 2 VSS: 4529 4528 4527 2 NAND2X2_HS $T=726800 30360 1 0 $X=726620 $Y=25915
X29505 VSS: 2 VSS: 4528 4526 4490 2 NOR2X2_HS $T=725420 30360 1 180 $X=722020 $Y=30095
X29514 VSS: 2 VSS: 1828 4529 2 BUFX16_HS $T=722200 38640 1 0 $X=722020 $Y=34195
X29538 VSS: 2 VSS: 2013 3024 2 CLKBUFX4 $T=726340 46920 0 0 $X=726160 $Y=46655
X29595 VSS: 2 VSS: 4566 3476 4424 4565 3440 2 AOI22X2_HS $T=742440 80040 0 180 $X=736740 $Y=75595
X29609 VSS: 2 VSS: 4530 4499 2 INVX16_HS $T=727720 88320 1 0 $X=727540 $Y=83875
X29617 VSS: 2 VSS: 3195 4500 2 BUFX8_HS $T=736920 88320 1 180 $X=731220 $Y=88055
X29624 VSS: 2 VSS: 4365 4501 2 BUFX4_HS $T=725420 96600 1 0 $X=725240 $Y=92155
X29636 VSS: 2 VSS: 4487 3438 4532 4531 4140 2 AOI22X2_HS $T=735540 96600 0 0 $X=735360 $Y=96335
X29644 VSS: 2 VSS: 4493 3247 4531 4532 918 2 AOI22X2_HS $T=736920 104880 0 180 $X=731220 $Y=100435
X29650 VSS: 2 VSS: 4531 7863 2627 3565 2 DFFX1_HS $T=722660 104880 0 0 $X=722480 $Y=104615
X29660 VSS: 2 VSS: 4533 4534 3615 2 NAND2X1 $T=733700 113160 1 0 $X=733520 $Y=108715
X29672 VSS: 2 VSS: 4534 4496 2312 2311 4531 2 AOI22X1 $T=727720 121440 0 180 $X=724780 $Y=116995
X29676 VSS: 2 VSS: 4565 7864 2677 3522 2 DFFX1_HS $T=735540 121440 1 0 $X=735360 $Y=116995
X29682 VSS: 2 VSS: 4532 7865 2627 3744 2 DFFX1_HS $T=730480 121440 0 0 $X=730300 $Y=121175
X29690 VSS: 2 VSS: 3440 4569 2 BUFX16_HS $T=740600 129720 0 180 $X=730300 $Y=125275
X29723 VSS: 2 VSS: 4536 4505 2 INVX16_HS $T=727720 146280 1 0 $X=727540 $Y=141835
X29730 VSS: 2 VSS: 4537 2767 1949 4506 3056 2 AOI22X1 $T=723580 146280 0 0 $X=723400 $Y=146015
X29879 VSS: 2 VSS: 3548 4507 2 CLKBUFX8 $T=721740 502320 0 0 $X=721560 $Y=502055
X29924 VSS: 2 VSS: 3424 4512 2 BUFX16_HS $T=723120 527160 0 0 $X=722940 $Y=526895
X29940 VSS: 2 VSS: 4538 4515 2 CLKINVX1 $T=727720 535440 0 0 $X=727540 $Y=535175
X29960 VSS: 2 VSS: 4515 4150 4152 2 NAND2X4_HS $T=738760 543720 1 180 $X=733520 $Y=543455
X29968 VSS: 2 VSS: 4468 4153 2 INVX8_HS $T=738760 552000 0 180 $X=733520 $Y=547555
X29973 VSS: 2 VSS: 1090 4539 2 BUFX16_HS $T=734620 552000 1 180 $X=724320 $Y=551735
X30008 VSS: 2 VSS: 4540 3196 4347 4378 3195 2 AOI22X2_HS $T=732780 576840 0 180 $X=727080 $Y=572395
X30016 VSS: 2 VSS: 4541 3195 4438 4380 3196 2 AOI22X1 $T=722200 576840 0 0 $X=722020 $Y=576575
X30029 VSS: 2 VSS: 4542 4302 3196 2 NAND2X2_HS $T=736460 585120 1 0 $X=736280 $Y=580675
X30033 VSS: 2 VSS: 4543 3196 4304 4410 3195 2 AOI22X2 $T=721280 585120 0 0 $X=721100 $Y=584855
X30042 VSS: 2 VSS: 4544 4545 4541 4519 4470 2 NAND4X2_HS $T=729100 593400 0 180 $X=723400 $Y=588955
X30060 VSS: 2 VSS: 4545 4301 4306 4133 3190 2 AOI22X1 $T=733240 601680 0 180 $X=730300 $Y=597235
X30068 VSS: 2 VSS: 4548 4547 4542 4546 2 NAND3X2_HS $T=731860 601680 1 180 $X=727080 $Y=601415
X30074 VSS: 2 VSS: 4549 4521 4550 4543 4447 2 NAND4X2_HS $T=726800 609960 0 180 $X=721100 $Y=605515
X30084 VSS: 2 VSS: 4547 4133 4232 4226 3190 2 AOI22X2_HS $T=730020 609960 0 0 $X=729840 $Y=609695
X30092 VSS: 2 VSS: 4550 4227 4308 4133 3190 2 AOI22X1_HS $T=729560 618240 1 0 $X=729380 $Y=613795
X30117 VSS: 2 VSS: 4551 4548 2 INVX2_HS $T=727260 626520 0 0 $X=727080 $Y=626255
X30126 VSS: 2 VSS: 4553 4552 4524 4551 2 NAND3X4_HS $T=724040 634800 1 0 $X=723860 $Y=630355
X30135 VSS: 2 VSS: 4552 4162 4230 4236 3401 2 AOI22X2 $T=728180 634800 0 0 $X=728000 $Y=634535
X30155 VSS: 2 VSS: 4554 7866 2627 3970 2 DFFX1_HS $T=746120 13800 1 0 $X=745940 $Y=9355
X30157 VSS: 2 VSS: 4558 4555 4557 4556 2 NAND3X2_HS $T=742900 13800 1 180 $X=738120 $Y=13535
X30162 VSS: 2 VSS: 4484 4558 4559 2 NOR2X4_HS $T=738300 22080 1 0 $X=738120 $Y=17635
X30168 VSS: 2 VSS: 4557 4391 4560 4554 3721 2 AOI22X1_HS $T=745200 22080 0 0 $X=745020 $Y=21815
X30176 VSS: 2 VSS: 4555 4561 4562 2 AND2X1_HS $T=746580 30360 1 180 $X=743640 $Y=30095
X30186 VSS: 2 VSS: 4591 7867 2627 3972 2 DFFX1_HS $T=749800 38640 0 0 $X=749620 $Y=38375
X30195 VSS: 2 VSS: 4563 7868 2677 3598 2 DFFX1_HS $T=738760 55200 1 0 $X=738580 $Y=50755
X30204 VSS: 2 VSS: 4564 7869 2627 3598 2 DFFX1_HS $T=738760 63480 1 0 $X=738580 $Y=59035
X30216 VSS: 2 VSS: 4599 4393 4424 4565 3432 2 AOI22X2_HS $T=752560 71760 1 0 $X=752380 $Y=67315
X30230 VSS: 2 VSS: 4600 3513 4604 4458 4365 2 AOI22X2 $T=753020 80040 0 0 $X=752840 $Y=79775
X30260 VSS: 2 VSS: 4608 4503 4533 2568 2 AOI21X1 $T=752560 113160 1 0 $X=752380 $Y=108715
X30265 VSS: 2 VSS: 4567 4565 2312 2311 4568 2 AOI22X1 $T=753940 113160 1 180 $X=751000 $Y=112895
X30269 VSS: 2 VSS: 4568 7870 2677 3565 2 DFFX1_HS $T=747960 121440 1 0 $X=747780 $Y=116995
X30279 VSS: 2 VSS: 4162 4535 2 BUFX16_HS $T=737840 129720 0 0 $X=737660 $Y=129455
X30286 VSS: 2 VSS: rdata_o[6] 3988 2 BUFX2 $T=750720 138000 1 0 $X=750540 $Y=133555
X30293 VSS: 2 VSS: 4571 2952 1949 4506 3050 2 AOI22X1 $T=751180 138000 0 0 $X=751000 $Y=137735
X30299 VSS: 2 VSS: 4572 410 wdata_i[21] 2 CLKAND2X2 $T=750260 146280 1 0 $X=750080 $Y=141835
X30302 VSS: 2 VSS: 3685 4573 2 CLKBUFX8 $T=744740 146280 1 180 $X=739500 $Y=146015
X30305 VSS: 2 VSS: 4612 3263 4506 1949 2765 2 AOI22X2 $T=750260 146280 0 0 $X=750080 $Y=146015
X30310 VSS: 2 VSS: rdata_o[11] 3619 2 BUFX2 $T=749340 502320 0 0 $X=749160 $Y=502055
X30314 VSS: 2 VSS: 4575 4576 2 BUFX16_HS $T=751180 510600 0 180 $X=740880 $Y=506155
X30317 VSS: 2 VSS: 4569 4576 2 BUFX16_HS $T=750720 510600 1 180 $X=740420 $Y=510335
X30321 VSS: 2 VSS: 4576 4182 4577 2 NOR2X4_HS $T=748420 518880 0 180 $X=743180 $Y=514435
X30326 VSS: 2 VSS: 3491 4576 2 BUFX16_HS $T=751640 518880 1 180 $X=741340 $Y=518615
X30338 VSS: 2 VSS: 4577 4538 4578 2 NAND2X2_HS $T=739220 535440 1 0 $X=739040 $Y=530995
X30345 VSS: 2 VSS: 4578 4579 2 INVX2_HS $T=739680 535440 0 0 $X=739500 $Y=535175
X30350 VSS: 2 VSS: 4579 4468 2 BUFX2_HS $T=738760 543720 1 0 $X=738580 $Y=539275
X30373 VSS: 2 VSS: 4580 4377 3196 3195 4434 2 AOI22X1_HS $T=749340 560280 0 180 $X=745940 $Y=555835
X30376 VSS: 2 VSS: 4583 4580 4517 4581 4516 2 NAND4X1_HS $T=742440 560280 1 180 $X=739040 $Y=560015
X30383 VSS: 2 VSS: 4582 4436 4584 2 NOR2X4_HS $T=740600 568560 1 0 $X=740420 $Y=564115
X30404 VSS: 2 VSS: 2799 4621 2 CLKBUFX8 $T=758540 585120 0 180 $X=753300 $Y=580675
X30408 VSS: 2 VSS: 4585 4381 3022 3205 4407 2 AOI22X1 $T=746580 585120 0 0 $X=746400 $Y=584855
X30417 VSS: 2 VSS: 4546 3195 4267 2 NAND2X2_HS $T=745200 593400 0 0 $X=745020 $Y=593135
X30423 VSS: 2 VSS: 4586 4382 3022 3205 4301 2 AOI22X1 $T=751640 601680 1 0 $X=751460 $Y=597235
X30442 VSS: 2 VSS: 4631 4384 3022 3205 4227 2 AOI22X1 $T=752560 618240 1 0 $X=752380 $Y=613795
X30445 VSS: 2 VSS: 4587 4133 4349 4228 3190 2 AOI22X2 $T=746120 618240 1 180 $X=741340 $Y=617975
X30454 VSS: 2 VSS: 404 4632 2 BUFX16_HS $T=753480 626520 1 0 $X=753300 $Y=622075
X30457 VSS: 2 VSS: 4588 4338 4384 4450 4096 2 AOI22X1_HS $T=751180 626520 1 180 $X=747780 $Y=626255
X30469 VSS: 2 VSS: 4589 4480 4525 4587 4540 2 NAND4X4_HS $T=747040 643080 0 180 $X=738120 $Y=638635
X30499 VSS: 2 VSS: 4594 4592 4638 4593 4590 2 NAND4X1_HS $T=768200 22080 0 0 $X=768020 $Y=21815
X30503 VSS: 2 VSS: 4527 4594 4595 2 NOR2X2_HS $T=763600 30360 1 0 $X=763420 $Y=25915
X30512 VSS: 2 VSS: 4593 4175 4564 4591 3737 2 AOI22X2 $T=764060 30360 0 0 $X=763880 $Y=30095
X30517 VSS: 2 VSS: 4562 1412 4564 4591 4392 2 AOI22X2_HS $T=759460 38640 1 0 $X=759280 $Y=34195
X30530 VSS: 2 VSS: 4492 4596 4598 4597 4456 2 AOI22X2_HS $T=765440 46920 0 180 $X=759740 $Y=42475
X30540 VSS: 2 VSS: 4486 4323 4598 4597 3424 2 AOI22X2_HS $T=764060 46920 0 0 $X=763880 $Y=46655
X30554 VSS: 2 VSS: 4641 4599 4600 4601 4640 2 NAND4X4_HS $T=765440 55200 0 0 $X=765260 $Y=54935
X30560 VSS: 2 VSS: 4642 4598 1695 1716 4564 2 AOI22X1 $T=768660 63480 1 0 $X=768480 $Y=59035
X30569 VSS: 2 VSS: 4643 4323 4639 4602 3424 2 AOI22X2_HS $T=769120 63480 0 0 $X=768940 $Y=63215
X30597 VSS: 2 VSS: 4603 3855 4458 4604 4366 2 AOI22X2_HS $T=771420 88320 0 180 $X=765720 $Y=83875
X30605 VSS: 2 VSS: 4592 3747 4503 4605 4606 2 AOI22X2_HS $T=763140 88320 0 0 $X=762960 $Y=88055
X30609 VSS: 2 VSS: 4561 4367 4503 4605 3774 2 AOI22X2_HS $T=764520 96600 0 180 $X=758820 $Y=92155
X30622 VSS: 2 VSS: 4644 3438 4607 4568 4140 2 AOI22X2 $T=766360 104880 1 0 $X=766180 $Y=100435
X30631 VSS: 2 VSS: 4601 3247 4568 4607 918 2 AOI22X2_HS $T=772800 104880 1 180 $X=767100 $Y=104615
X30647 VSS: 2 VSS: 3522 4609 2 CLKBUFX8 $T=764520 121440 0 180 $X=759280 $Y=116995
X30650 VSS: 2 VSS: 4606 3497 2 BUFX16_HS $T=778780 121440 0 180 $X=768480 $Y=116995
X30656 VSS: 2 VSS: 4607 7871 2677 3744 2 DFFX1_HS $T=759920 121440 0 0 $X=759740 $Y=121175
X30659 VSS: 2 VSS: 3598 4610 2 CLKBUFX8 $T=759920 129720 0 180 $X=754680 $Y=125275
X30663 VSS: 2 VSS: 3513 4611 2 BUFX16_HS $T=766360 129720 1 0 $X=766180 $Y=125275
X30673 VSS: 2 VSS: 3744 4651 2 CLKBUFX8 $T=773720 129720 1 180 $X=768480 $Y=129455
X30688 VSS: 2 VSS: 705 4611 2 BUFX16_HS $T=761760 146280 1 0 $X=761580 $Y=141835
X30785 VSS: 2 VSS: 4510 4068 4613 2 NOR2X4_HS $T=770040 510600 0 0 $X=769860 $Y=510335
X30799 VSS: 2 VSS: 4614 4402 4613 2 NOR2X4_HS $T=757620 527160 1 0 $X=757440 $Y=522715
X30803 VSS: 2 VSS: 3862 4659 2 CLKBUFX8 $T=770960 527160 0 180 $X=765720 $Y=522715
X30808 VSS: 2 VSS: 3313 4615 2 BUFX16_HS $T=764520 527160 1 180 $X=754220 $Y=526895
X30812 VSS: 2 VSS: 2577 4610 2 CLKBUFX8 $T=761300 535440 0 180 $X=756060 $Y=530995
X30813 VSS: 2 VSS: 4615 4616 4182 2 NOR2X2_HS $T=764520 535440 0 180 $X=761120 $Y=530995
X30820 VSS: 2 VSS: 3540 4614 2 BUFX16_HS $T=755780 535440 0 0 $X=755600 $Y=535175
X30834 VSS: 2 VSS: 4660 4262 2 BUFX8_HS $T=766820 543720 0 0 $X=766640 $Y=543455
X30842 VSS: 2 VSS: 4617 4262 2 BUFX16_HS $T=764060 552000 1 180 $X=753760 $Y=551735
X30854 VSS: 2 VSS: 4539 4582 4618 2 NAND2X2_HS $T=761300 560280 0 0 $X=761120 $Y=560015
X30866 VSS: 2 VSS: 4581 4133 3190 4407 4348 2 AOI22X1 $T=757620 568560 1 180 $X=754680 $Y=568295
X30873 VSS: 2 VSS: 2504 4619 2 BUFX16_HS $T=756240 576840 1 0 $X=756060 $Y=572395
X30880 VSS: 2 VSS: 2737 4620 2 BUFX16_HS $T=758080 576840 0 0 $X=757900 $Y=576575
X30884 VSS: 2 VSS: 4620 4622 4623 2 NAND2X2_HS $T=764520 585120 0 180 $X=761120 $Y=580675
X30894 VSS: 2 VSS: 4623 4443 4624 2 NOR2X2_HS $T=763600 585120 0 0 $X=763420 $Y=584855
X30901 VSS: 2 VSS: 2761 4625 2 BUFX16_HS $T=768660 593400 1 0 $X=768480 $Y=588955
X30918 VSS: 2 VSS: 4627 4549 4626 2 NOR2X2_HS $T=755780 601680 0 0 $X=755600 $Y=601415
X30924 VSS: 2 VSS: 4619 4627 4628 2 NAND2X2_HS $T=756700 609960 1 0 $X=756520 $Y=605515
X30934 VSS: 2 VSS: 4628 4629 4630 2 NOR2X2_HS $T=756700 609960 0 0 $X=756520 $Y=609695
X30960 VSS: 2 VSS: 4632 4634 4633 2 NAND2X2_HS $T=759920 634800 0 180 $X=756520 $Y=630355
X30968 VSS: 2 VSS: 4634 4479 4635 2 NOR2X4_HS $T=758540 634800 0 0 $X=758360 $Y=634535
X30986 VSS: 2 VSS: 4590 4453 4636 4637 4313 2 AOI22X2_HS $T=774180 13800 0 0 $X=774000 $Y=13535
X30994 VSS: 2 VSS: 4638 3725 4554 4560 3810 2 AOI22X2_HS $T=776940 22080 1 0 $X=776760 $Y=17635
X31010 VSS: 2 VSS: 4685 4554 3024 2012 4637 2 AOI22X1 $T=786140 30360 1 0 $X=785960 $Y=25915
X31024 VSS: 2 VSS: 4596 4454 2 CLKBUFX2 $T=781540 38640 1 180 $X=779060 $Y=38375
X31041 VSS: 2 VSS: 4640 4596 4639 4602 4456 2 AOI22X2_HS $T=770500 55200 1 0 $X=770320 $Y=50755
X31070 VSS: 2 VSS: 4645 4644 4643 4566 4603 2 NAND4X4_HS $T=779700 71760 1 180 $X=770780 $Y=71495
X31077 VSS: 2 VSS: 4598 7872 2627 136 2 DFFX1_HS $T=773720 80040 1 0 $X=773540 $Y=75595
X31108 VSS: 2 VSS: 4605 7873 2627 3942 2 DFFX1_HS $T=778320 96600 0 0 $X=778140 $Y=96335
X31125 VSS: 2 VSS: 2006 3045 2 CLKBUFX4 $T=772340 113160 1 0 $X=772160 $Y=108715
X31130 VSS: 2 VSS: 4648 4567 4646 2 NAND2X1 $T=770500 113160 0 0 $X=770320 $Y=112895
X31133 VSS: 2 VSS: 3565 4647 2 CLKBUFX8 $T=778780 113160 1 180 $X=773540 $Y=112895
X31137 VSS: 2 VSS: 4694 4502 4648 2568 2 AOI21X1 $T=786600 113160 0 0 $X=786420 $Y=112895
X31143 VSS: 2 VSS: 918 4649 2 BUFX16_HS $T=784300 121440 1 0 $X=784120 $Y=116995
X31153 VSS: 2 VSS: 4650 3129 1949 4506 3053 2 AOI22X1 $T=780620 129720 1 0 $X=780440 $Y=125275
X31165 VSS: 2 VSS: 4646 4652 1949 4506 3076 2 AOI22X1 $T=774640 138000 1 0 $X=774460 $Y=133555
X31171 VSS: 2 VSS: 4652 4653 2 BUFX2 $T=778320 138000 1 180 $X=775840 $Y=137735
X31183 VSS: 2 VSS: 4655 4654 1949 410 2891 2 AOI22X1 $T=782460 146280 1 0 $X=782280 $Y=141835
X31188 VSS: 2 VSS: 3552 4621 2 CLKBUFX8 $T=783380 146280 1 180 $X=778140 $Y=146015
X31191 VSS: 2 VSS: 4656 2770 1949 4506 3049 2 AOI22X1 $T=787520 146280 1 180 $X=784580 $Y=146015
X31268 VSS: 2 VSS: 4366 3313 2 BUFX8_HS $T=775100 502320 0 0 $X=774920 $Y=502055
X31276 VSS: 2 VSS: 4657 4510 2 BUFX16_HS $T=772800 510600 1 0 $X=772620 $Y=506155
X31289 VSS: 2 VSS: 4613 4658 4153 2 OR2X2_HS $T=778780 518880 0 180 $X=775380 $Y=514435
X31297 VSS: 2 VSS: 4658 4150 4152 2 NAND2X4_HS $T=790740 518880 1 180 $X=785500 $Y=518615
X31305 VSS: 2 VSS: 3755 4702 2 CLKBUFX8 $T=787520 527160 0 180 $X=782280 $Y=522715
X31309 VSS: 2 VSS: 4616 4658 4153 2 OR2X1 $T=780620 527160 1 180 $X=778140 $Y=526895
X31320 VSS: 2 VSS: 4705 4512 2 BUFX16_HS $T=784300 535440 1 0 $X=784120 $Y=530995
X31342 VSS: 2 VSS: 840 4661 2 BUFX16_HS $T=772800 552000 1 0 $X=772620 $Y=547555
X31348 VSS: 2 VSS: 4661 4662 4663 2 NAND2X2_HS $T=781080 552000 1 180 $X=777680 $Y=551735
X31355 VSS: 2 VSS: 2800 4664 2 CLKBUFX8 $T=776940 560280 0 180 $X=771700 $Y=555835
X31362 VSS: 2 VSS: 4663 4583 4666 2 NOR2X2_HS $T=781080 560280 0 0 $X=780900 $Y=560015
X31372 VSS: 2 VSS: 4665 4681 4381 4446 3181 2 AOI22X2_HS $T=790740 568560 0 180 $X=785040 $Y=564115
X31377 VSS: 2 VSS: 4667 4338 4381 4446 4096 2 AOI22X1 $T=779240 568560 0 0 $X=779060 $Y=568295
X31400 VSS: 2 VSS: 4668 4669 4413 4473 2546 2 AOI22X1_HS $T=783380 585120 1 0 $X=783200 $Y=580675
X31406 VSS: 2 VSS: 4670 2595 2596 4473 4413 2 AOI22X1_HS $T=783380 585120 0 0 $X=783200 $Y=584855
X31416 VSS: 2 VSS: 4625 4671 4672 2 NAND2X2_HS $T=775100 593400 1 180 $X=771700 $Y=593135
X31424 VSS: 2 VSS: 4671 4673 4544 2 NOR2X2_HS $T=776020 601680 0 180 $X=772620 $Y=597235
X31430 VSS: 2 VSS: 4674 4338 4382 4417 4096 2 AOI22X1_HS $T=781080 601680 1 180 $X=777680 $Y=601415
X31445 VSS: 2 VSS: 4675 4475 2606 2808 4417 2 AOI22X1 $T=777860 609960 0 0 $X=777680 $Y=609695
X31453 VSS: 2 VSS: 4629 4677 4678 4676 2 NAND3X2_HS $T=785680 618240 0 180 $X=780900 $Y=613795
X31458 VSS: 2 VSS: 4676 4679 4384 4450 3356 2 AOI22X2_HS $T=774640 618240 0 0 $X=774460 $Y=617975
X31470 VSS: 2 VSS: 4680 4478 2606 2808 4450 2 AOI22X1 $T=774180 626520 0 0 $X=774000 $Y=626255
X31479 VSS: 2 VSS: 4679 4681 2 BUFX2_HS $T=778320 634800 0 180 $X=775380 $Y=630355
X31488 VSS: 2 VSS: 4682 4417 4681 2 NAND2X1 $T=781540 634800 0 0 $X=781360 $Y=634535
X31498 VSS: 2 VSS: 4714 4382 3181 2 NAND2X4_HS $T=783380 643080 1 0 $X=783200 $Y=638635
X31506 VSS: 2 VSS: 4556 4312 4636 4637 4683 2 AOI22X2_HS $T=791660 13800 1 0 $X=791480 $Y=9355
X31519 VSS: 2 VSS: 4637 7874 2627 3971 2 DFFX1_HS $T=793500 22080 0 0 $X=793320 $Y=21815
X31527 VSS: 2 VSS: 4686 4175 4563 4684 3737 2 AOI22X2 $T=792580 30360 0 0 $X=792400 $Y=30095
X31539 VSS: 2 VSS: 4687 4563 4684 4392 1412 2 AOI22X1_HS $T=803620 38640 1 180 $X=800220 $Y=38375
X31542 VSS: 2 VSS: 4392 4688 2 BUFX8_HS $T=800400 46920 0 180 $X=794700 $Y=42475
X31552 VSS: 2 VSS: 4688 3867 2 BUFX2_HS $T=796260 55200 1 0 $X=796080 $Y=50755
X31561 VSS: 2 VSS: 4689 4639 1695 1716 4563 2 AOI22X1 $T=792580 63480 1 0 $X=792400 $Y=59035
X31572 VSS: 2 VSS: 4456 4690 2 BUFX8_HS $T=792580 71760 1 0 $X=792400 $Y=67315
X31583 VSS: 2 VSS: 4639 7875 2677 136 2 DFFX1_HS $T=798560 80040 1 0 $X=798380 $Y=75595
X31586 VSS: 2 VSS: 4691 4459 3045 2007 4605 2 AOI22X1 $T=788440 80040 0 0 $X=788260 $Y=79775
X31604 VSS: 2 VSS: 4692 4502 4731 3774 4367 2 AOI22X1_HS $T=804540 96600 0 180 $X=801140 $Y=92155
X31610 VSS: 2 VSS: 4731 7876 2677 3942 2 DFFX1_HS $T=800860 96600 0 0 $X=800680 $Y=96335
X31615 VSS: 2 VSS: 3942 4732 2 CLKBUFX8 $T=807300 104880 0 180 $X=802060 $Y=100435
X31620 VSS: 2 VSS: 4604 7877 2677 3676 2 DFFX1_HS $T=800400 104880 0 0 $X=800220 $Y=104615
X31623 VSS: 2 VSS: 4690 4693 2 BUFX2 $T=789360 113160 1 0 $X=789180 $Y=108715
X31635 VSS: 2 VSS: 4649 4695 2 BUFX2_HS $T=790280 121440 1 180 $X=787340 $Y=121175
X31647 VSS: 2 VSS: 3141 4696 2 CLKBUFX4 $T=798560 129720 1 180 $X=795620 $Y=129455
X31652 VSS: 2 VSS: 4698 4697 1949 410 3074 2 AOI22X1 $T=795340 138000 0 180 $X=792400 $Y=133555
X31660 VSS: 2 VSS: 4699 4698 2 BUFX2 $T=796260 138000 0 0 $X=796080 $Y=137735
X31673 VSS: 2 VSS: 4743 4655 2 BUFX2 $T=801780 146280 0 0 $X=801600 $Y=146015
X31678 VSS: 2 VSS: rdata_o[25] 2788 2 BUFX2 $T=794880 502320 0 0 $X=794700 $Y=502055
X31686 VSS: 2 VSS: 4700 4537 2 BUFX2 $T=790740 510600 0 0 $X=790560 $Y=510335
X31698 VSS: 2 VSS: 4704 4658 4153 2 OR2X1_HS $T=787520 527160 1 0 $X=787340 $Y=522715
X31706 VSS: 2 VSS: 3752 4703 2 CLKBUFX4 $T=799020 527160 0 0 $X=798840 $Y=526895
X31713 VSS: 2 VSS: 4703 4222 4704 2 NOR2X4_HS $T=794420 535440 1 180 $X=789180 $Y=535175
X31721 VSS: 2 VSS: 2546 4749 2 BUFX16_HS $T=810980 543720 0 180 $X=800680 $Y=539275
X31735 VSS: 2 VSS: 4662 4706 4707 2 NOR2X2_HS $T=803620 552000 1 180 $X=800220 $Y=551735
X31739 VSS: 2 VSS: 4707 4665 4668 4708 4750 2 NAND4X2_HS $T=799020 560280 1 0 $X=798840 $Y=555835
X31753 VSS: 2 VSS: 4756 7878 2696 4751 2 DFFX1_HS $T=802240 568560 0 0 $X=802060 $Y=568295
X31778 VSS: 2 VSS: 4672 4709 4710 2 NOR2X2_HS $T=796720 593400 0 0 $X=796540 $Y=593135
X31789 VSS: 2 VSS: 4711 2595 4414 4475 2596 2 AOI22X1 $T=798100 601680 0 0 $X=797920 $Y=601415
X31795 VSS: 2 VSS: 4712 2546 4475 4414 4669 2 AOI22X2 $T=796260 609960 1 0 $X=796080 $Y=605515
X31802 VSS: 2 VSS: 4710 4766 4712 4767 2 NAND3X2_HS $T=801780 609960 0 0 $X=801600 $Y=609695
X31816 VSS: 2 VSS: 4769 4669 4416 4478 2546 2 AOI22X2_HS $T=800860 626520 1 0 $X=800680 $Y=622075
X31820 VSS: 2 VSS: 4713 2595 4416 4478 2596 2 AOI22X1_HS $T=799020 626520 0 0 $X=798840 $Y=626255
X31827 VSS: 2 VSS: 4766 4772 4771 2 NOR2X2_HS $T=802700 634800 1 0 $X=802520 $Y=630355
X31833 VSS: 2 VSS: 4772 4714 4682 2 NAND2X2_HS $T=802700 634800 0 0 $X=802520 $Y=634535
X31852 VSS: 2 VSS: 4716 4312 4715 4717 4683 2 AOI22X2 $T=818800 13800 1 180 $X=814020 $Y=13535
X31861 VSS: 2 VSS: 4718 4453 4715 4717 4313 2 AOI22X2 $T=817880 22080 0 180 $X=813100 $Y=17635
X31876 VSS: 2 VSS: 4720 4718 4686 4719 4721 2 NAND4X2_HS $T=811900 30360 1 0 $X=811720 $Y=25915
X31885 VSS: 2 VSS: 4721 3725 4774 4773 3810 2 AOI22X2_HS $T=819260 30360 0 0 $X=819080 $Y=30095
X31891 VSS: 2 VSS: 4723 4687 4692 4722 4716 2 NAND4X2_HS $T=810980 38640 1 0 $X=810800 $Y=34195
X31916 VSS: 2 VSS: 4725 4720 4724 2 NOR2X2_HS $T=809600 46920 0 0 $X=809420 $Y=46655
X31925 VSS: 2 VSS: 4391 4726 2 BUFX8_HS $T=817420 55200 1 0 $X=817240 $Y=50755
X31932 VSS: 2 VSS: 4727 4725 4728 2 NAND2X2_HS $T=813280 55200 1 180 $X=809880 $Y=54935
X31940 VSS: 2 VSS: 520 4727 2 BUFX16_HS $T=810060 63480 1 0 $X=809880 $Y=59035
X31945 VSS: 2 VSS: 4393 4729 2 BUFX8 $T=810060 63480 1 180 $X=804820 $Y=63215
X31969 VSS: 2 VSS: 3715 4781 2 BUFX8 $T=821100 80040 0 180 $X=815860 $Y=75595
X31978 VSS: 2 VSS: 4726 4426 2 BUFX2_HS $T=821100 80040 1 180 $X=818160 $Y=79775
X31982 VSS: 2 VSS: 4730 4458 3045 2007 4731 2 AOI22X1 $T=803160 88320 1 0 $X=802980 $Y=83875
X31991 VSS: 2 VSS: 4719 3747 4502 4731 3741 2 AOI22X2_HS $T=803620 88320 0 0 $X=803440 $Y=88055
X32014 VSS: 2 VSS: 4498 7879 2627 3676 2 DFFX1_HS $T=807760 104880 1 0 $X=807580 $Y=100435
X32027 VSS: 2 VSS: 3774 4733 2 BUFX16_HS $T=816040 113160 0 180 $X=805740 $Y=108715
X32033 VSS: 2 VSS: 1149 4693 2 BUFX16_HS $T=804540 113160 0 0 $X=804360 $Y=112895
X32040 VSS: 2 VSS: 4734 4735 1949 4506 3052 2 AOI22X1 $T=805920 121440 1 0 $X=805740 $Y=116995
X32048 VSS: 2 VSS: 4736 4737 1949 4506 3054 2 AOI22X1 $T=805920 121440 0 0 $X=805740 $Y=121175
X32059 VSS: 2 VSS: 4789 3059 4506 1949 4738 2 AOI22X2_HS $T=815120 129720 1 0 $X=814940 $Y=125275
X32067 VSS: 2 VSS: 4696 4739 2 BUFX2_HS $T=814660 129720 1 180 $X=811720 $Y=129455
X32078 VSS: 2 VSS: 4740 1641 4653 2 AND2X1_HS $T=821560 138000 0 180 $X=818620 $Y=133555
X32086 VSS: 2 VSS: 4741 1364 4740 2 AND2X1_HS $T=819720 138000 1 180 $X=816780 $Y=137735
X32094 VSS: 2 VSS: 4150 4741 2 BUFX16_HS $T=812360 146280 1 0 $X=812180 $Y=141835
X32101 VSS: 2 VSS: 4742 4058 2 CLKBUFX8 $T=807300 146280 0 0 $X=807120 $Y=146015
X32105 VSS: 2 VSS: 4745 4744 1949 4506 3061 2 AOI22X1 $T=817420 146280 0 0 $X=817240 $Y=146015
X32260 VSS: 2 VSS: 4747 1641 4737 2 AND2X1_HS $T=807300 510600 1 0 $X=807120 $Y=506155
X32270 VSS: 2 VSS: 4748 1364 4747 2 AND2X1_HS $T=810060 510600 1 180 $X=807120 $Y=510335
X32278 VSS: 2 VSS: 4153 4748 2 BUFX8_HS $T=805460 518880 1 0 $X=805280 $Y=514435
X32293 VSS: 2 VSS: 4140 4703 2 BUFX16_HS $T=808680 527160 1 0 $X=808500 $Y=522715
X32308 VSS: 2 VSS: 2997 4703 2 BUFX16_HS $T=816960 535440 0 180 $X=806660 $Y=530995
X32331 VSS: 2 VSS: 925 4729 2 BUFX16_HS $T=827080 543720 1 180 $X=816780 $Y=543455
X32340 VSS: 2 VSS: 4750 4752 4768 2 NAND2X4_HS $T=822480 552000 0 180 $X=817240 $Y=547555
X32348 VSS: 2 VSS: 4798 7880 2746 4751 2 DFFX1_HS $T=815120 552000 0 0 $X=814940 $Y=551735
X32361 VSS: 2 VSS: 4618 4754 4753 2 NOR2X2_HS $T=808220 560280 0 0 $X=808040 $Y=560015
X32370 VSS: 2 VSS: 4070 4755 2 CLKBUFX8 $T=811900 568560 0 180 $X=806660 $Y=564115
X32373 VSS: 2 VSS: 4800 7881 1926 4751 2 DFFX1_HS $T=814200 568560 1 0 $X=814020 $Y=564115
X32386 VSS: 2 VSS: 4754 4757 4670 4667 4758 2 NAND4X2_HS $T=807760 576840 1 0 $X=807580 $Y=572395
X32394 VSS: 2 VSS: 4759 4070 2 CLKBUFX8 $T=806840 576840 0 0 $X=806660 $Y=576575
X32395 VSS: 2 VSS: 4758 4752 3843 2 NAND2X2 $T=814200 576840 1 180 $X=811720 $Y=576575
X32402 VSS: 2 VSS: 4622 4760 4761 2 NOR2X2_HS $T=805460 585120 1 0 $X=805280 $Y=580675
X32410 VSS: 2 VSS: 4762 4473 2606 2808 4446 2 AOI22X1 $T=803620 585120 0 0 $X=803440 $Y=584855
X32421 VSS: 2 VSS: 4806 7882 2696 4759 2 DFFX1_HS $T=812820 593400 1 0 $X=812640 $Y=588955
X32433 VSS: 2 VSS: 4760 4674 4711 4763 4764 2 NAND4X2_HS $T=803620 601680 1 0 $X=803440 $Y=597235
X32445 VSS: 2 VSS: 4764 4765 3843 2 NAND2X1 $T=815120 601680 0 0 $X=814940 $Y=601415
X32470 VSS: 2 VSS: 4767 4765 4768 2 NAND2X1 $T=814660 618240 0 180 $X=812640 $Y=613795
X32477 VSS: 2 VSS: 4677 4769 4770 2 AND2X1_HS $T=805920 618240 1 180 $X=802980 $Y=617975
X32516 VSS: 2 VSS: 2600 4749 2 BUFX16_HS $T=809600 643080 1 0 $X=809420 $Y=638635
X32541 VSS: 2 VSS: 4636 7883 2627 4010 2 DFFX1_HS $T=830760 22080 0 0 $X=830580 $Y=21815
X32557 VSS: 2 VSS: 4775 4774 2013 2012 4717 2 AOI22X1 $T=827080 38640 0 0 $X=826900 $Y=38375
X32560 VSS: 2 VSS: 4722 4391 4773 4774 3721 2 AOI22X1 $T=820640 46920 1 0 $X=820460 $Y=42475
X32568 VSS: 2 VSS: 4777 4776 4723 2 NOR2X2_HS $T=834440 46920 1 180 $X=831040 $Y=46655
X32577 VSS: 2 VSS: 4778 4777 4779 2 NAND2X2_HS $T=831680 55200 0 0 $X=831500 $Y=54935
X32586 VSS: 2 VSS: 2632 4778 2 BUFX16_HS $T=826620 63480 0 0 $X=826440 $Y=63215
X32588 VSS: 2 VSS: 4728 4780 4645 2 NOR2X2_HS $T=823860 71760 0 180 $X=820460 $Y=67315
X32595 VSS: 2 VSS: 1412 4781 2 BUFX16_HS $T=825700 71760 0 0 $X=825520 $Y=71495
X32600 VSS: 2 VSS: 3880 4823 2 BUFX16_HS $T=842720 80040 0 180 $X=832420 $Y=75595
X32607 VSS: 2 VSS: 4783 4782 2785 2796 4498 2 AOI22X1 $T=825240 88320 1 0 $X=825060 $Y=83875
X32619 VSS: 2 VSS: rdata_o[13] 4783 4785 4784 4608 2 NAND4X1_HS $T=826160 96600 1 0 $X=825980 $Y=92155
X32624 VSS: 2 VSS: 4784 4787 2991 2992 4532 2 AOI22X1 $T=826620 96600 0 0 $X=826440 $Y=96335
X32635 VSS: 2 VSS: 3976 4788 2 CLKBUFX8_HS $T=835820 104880 1 180 $X=826900 $Y=104615
X32655 VSS: 2 VSS: 3453 4830 2 BUFX16_HS $T=839500 121440 1 180 $X=829200 $Y=121175
X32692 VSS: 2 VSS: 4791 813 2450 2 NAND2X4_HS $T=831680 510600 1 0 $X=831500 $Y=506155
X32696 VSS: 2 VSS: 4792 813 2636 2 NAND2X4_HS $T=827540 510600 0 0 $X=827360 $Y=510335
X32702 VSS: 2 VSS: 4793 1364 4838 2 AND2X1_HS $T=836740 518880 0 180 $X=833800 $Y=514435
X32706 VSS: 2 VSS: 4152 4793 2 BUFX8_HS $T=830760 518880 1 180 $X=825060 $Y=518615
X32716 VSS: 2 VSS: 4790 4163 2 BUFX16_HS $T=826620 527160 0 0 $X=826440 $Y=526895
X32724 VSS: 2 VSS: 4795 4703 2 BUFX16_HS $T=822480 535440 0 0 $X=822300 $Y=535175
X32744 VSS: 2 VSS: 4708 4794 4798 4799 4796 2 AOI22X1_HS $T=832140 560280 1 0 $X=831960 $Y=555835
X32756 VSS: 2 VSS: 4802 4348 2555 2564 4801 2 AOI22X1 $T=832600 568560 1 180 $X=829660 $Y=568295
X32766 VSS: 2 VSS: 4803 4804 4762 4802 4797 2 NAND4X1 $T=830760 576840 0 0 $X=830580 $Y=576575
X32771 VSS: 2 VSS: 4804 4377 2317 2319 4805 2 AOI22X1 $T=833520 585120 0 180 $X=830580 $Y=580675
X32776 VSS: 2 VSS: 4805 7884 2746 4759 2 DFFX1_HS $T=827540 585120 0 0 $X=827360 $Y=584855
X32781 VSS: 2 VSS: 4807 4380 2317 2319 4806 2 AOI22X1 $T=820180 593400 0 0 $X=820000 $Y=593135
X32796 VSS: 2 VSS: 4808 4807 4675 4810 4809 2 NAND4X1 $T=831220 601680 0 0 $X=831040 $Y=601415
X32801 VSS: 2 VSS: 4810 4306 2555 2564 4811 2 AOI22X1 $T=833520 609960 0 180 $X=830580 $Y=605515
X32805 VSS: 2 VSS: 4752 7885 2746 4812 2 DFFX1_HS $T=822480 609960 0 0 $X=822300 $Y=609695
X32813 VSS: 2 VSS: 4765 7886 2696 4812 2 DFFX1_HS $T=822480 618240 0 0 $X=822300 $Y=617975
X32817 VSS: 2 VSS: 4813 4106 2 CLKBUFX2 $T=825240 626520 0 180 $X=822760 $Y=622075
X32825 VSS: 2 VSS: 4801 7887 2746 4813 2 DFFX1_HS $T=827540 626520 0 0 $X=827360 $Y=626255
X32827 VSS: 2 VSS: 4811 7888 2696 4813 2 DFFX1_HS $T=821560 634800 1 0 $X=821380 $Y=630355
X32834 VSS: 2 VSS: 4771 4861 4814 2 NAND2X2_HS $T=836740 634800 1 180 $X=833340 $Y=634535
X32841 VSS: 2 VSS: 4683 3801 2 BUFX8_HS $T=838580 13800 1 0 $X=838400 $Y=9355
X32858 VSS: 2 VSS: 4715 7889 2677 4010 2 DFFX1_HS $T=847780 22080 1 0 $X=847600 $Y=17635
X32868 VSS: 2 VSS: 4774 7890 2677 3970 2 DFFX1_HS $T=838580 30360 1 0 $X=838400 $Y=25915
X32870 VSS: 2 VSS: 4010 4864 2 CLKBUFX8 $T=853300 30360 0 180 $X=848060 $Y=25915
X32877 VSS: 2 VSS: 4717 7891 2677 3971 2 DFFX1_HS $T=841800 30360 0 0 $X=841620 $Y=30095
X32884 VSS: 2 VSS: 4815 4422 4818 4817 4816 2 AOI22X1_HS $T=852380 38640 0 180 $X=848980 $Y=34195
X32889 VSS: 2 VSS: 3970 4819 2 CLKBUFX8 $T=842720 38640 1 180 $X=837480 $Y=38375
X32892 VSS: 2 VSS: 4820 4817 2317 2319 4715 2 AOI22X1 $T=848240 38640 0 0 $X=848060 $Y=38375
X32907 VSS: 2 VSS: 4868 3870 4817 4818 4839 2 AOI22X2 $T=850540 46920 0 0 $X=850360 $Y=46655
X32910 VSS: 2 VSS: 4817 7892 2677 4136 2 DFFX1_HS $T=845020 55200 1 0 $X=844840 $Y=50755
X32918 VSS: 2 VSS: 4779 4821 4641 2 NOR2X2_HS $T=839040 63480 0 180 $X=835640 $Y=59035
X32932 VSS: 2 VSS: 4816 4822 2 BUFX2 $T=851000 63480 0 0 $X=850820 $Y=63215
X32935 VSS: 2 VSS: 4823 4822 2 CLKBUFX4 $T=845940 71760 0 180 $X=843000 $Y=67315
X32954 VSS: 2 VSS: 4394 4822 2 INVX8_HS $T=839500 80040 0 0 $X=839320 $Y=79775
X32959 VSS: 2 VSS: 4782 7893 2627 4116 2 DFFX1_HS $T=840880 88320 1 0 $X=840700 $Y=83875
X32968 VSS: 2 VSS: 4818 7894 2677 4116 2 DFFX1_HS $T=841800 88320 0 0 $X=841620 $Y=88055
X32975 VSS: 2 VSS: 4824 4818 2785 2796 4604 2 AOI22X1 $T=849160 96600 1 0 $X=848980 $Y=92155
X32985 VSS: 2 VSS: 4828 7895 2677 4138 2 DFFX1_HS $T=850080 96600 0 0 $X=849900 $Y=96335
X32990 VSS: 2 VSS: rdata_o[18] 4824 4825 4826 4694 2 NAND4X1_HS $T=852380 104880 0 180 $X=848980 $Y=100435
X32998 VSS: 2 VSS: 4826 4828 2991 2992 4607 2 AOI22X1 $T=850540 104880 0 0 $X=850360 $Y=104615
X33002 VSS: 2 VSS: 3979 4873 2 INVX8_HS $T=854220 113160 0 180 $X=848980 $Y=108715
X33007 VSS: 2 VSS: 4830 4829 4831 2 NOR2X4_HS $T=837660 113160 0 0 $X=837480 $Y=112895
X33011 VSS: 2 VSS: 4535 4829 4831 2 NOR2X4_HS $T=835820 121440 1 0 $X=835640 $Y=116995
X33027 VSS: 2 VSS: 4738 4832 2 BUFX2 $T=852840 129720 0 180 $X=850360 $Y=125275
X33033 VSS: 2 VSS: 4833 1822 1808 2 NAND2X4_HS $T=837200 129720 0 0 $X=837020 $Y=129455
X33040 VSS: 2 VSS: 1982 4834 2 BUFX16_HS $T=851460 138000 0 180 $X=841160 $Y=133555
X33046 VSS: 2 VSS: 4835 4571 2 BUFX2 $T=837200 138000 0 0 $X=837020 $Y=137735
X33051 VSS: 2 VSS: 4697 4878 2 BUFX2 $T=853760 138000 1 180 $X=851280 $Y=137735
X33054 VSS: 2 VSS: 4341 4836 2 BUFX8_HS $T=841800 146280 1 0 $X=841620 $Y=141835
X33063 VSS: 2 VSS: 4836 1364 4837 2 AND2X1_HS $T=844560 146280 1 180 $X=841620 $Y=146015
X33064 VSS: 2 VSS: 4837 1641 4430 2 AND2X1_HS $T=847320 146280 1 180 $X=844380 $Y=146015
X33164 VSS: 2 VSS: 4839 3531 2 INVX16_HS $T=843640 527160 1 0 $X=843460 $Y=522715
X33176 VSS: 2 VSS: 926 4840 2 BUFX16_HS $T=851000 535440 0 180 $X=840700 $Y=530995
X33186 VSS: 2 VSS: 4794 4885 2 BUFX4_HS $T=855140 535440 1 180 $X=851280 $Y=535175
X33204 VSS: 2 VSS: 4797 4799 2320 2558 4842 2 AOI22X1 $T=852380 552000 0 180 $X=849440 $Y=547555
X33208 VSS: 2 VSS: 4843 4752 1701 1726 4841 2 AOI22X1 $T=839040 552000 1 180 $X=836100 $Y=551735
X33227 VSS: 2 VSS: 4757 4845 4798 4799 1683 2 AOI22X1_HS $T=840420 568560 0 180 $X=837020 $Y=564115
X33243 VSS: 2 VSS: 4848 4847 4846 4472 4843 2 NAND4X1 $T=841800 576840 1 0 $X=841620 $Y=572395
X33254 VSS: 2 VSS: 4891 4803 4892 4848 2 NOR3X1 $T=851920 576840 0 0 $X=851740 $Y=576575
X33259 VSS: 2 VSS: 4845 4072 2 INVX4 $T=851920 585120 1 0 $X=851740 $Y=580675
X33271 VSS: 2 VSS: 4851 4850 4520 4849 4586 2 NAND4X1 $T=848700 593400 0 180 $X=845760 $Y=588955
X33279 VSS: 2 VSS: 4852 4765 1701 1726 4844 2 AOI22X1 $T=843640 593400 1 180 $X=840700 $Y=593135
X33286 VSS: 2 VSS: 4854 4808 4851 4853 2 NOR3X1 $T=846860 601680 1 0 $X=846680 $Y=597235
X33296 VSS: 2 VSS: 4853 4855 4898 4474 4852 2 NAND4X1 $T=851000 601680 0 0 $X=850820 $Y=601415
X33306 VSS: 2 VSS: 4856 7896 2746 4074 2 DFFX1_HS $T=837200 609960 0 0 $X=837020 $Y=609695
X33310 VSS: 2 VSS: 4857 7897 2696 4074 2 DFFX1_HS $T=840420 618240 1 0 $X=840240 $Y=613795
X33320 VSS: 2 VSS: 4106 4859 2 CLKBUFX4 $T=839960 626520 0 180 $X=837020 $Y=622075
X33322 VSS: 2 VSS: 4858 7898 1926 4074 2 DFFX1_HS $T=840880 626520 1 0 $X=840700 $Y=622075
X33335 VSS: 2 VSS: 4860 4796 2 CLKBUFX2 $T=846400 634800 0 180 $X=843920 $Y=630355
X33347 VSS: 2 VSS: 4814 4756 4860 2 NAND2X2_HS $T=841800 643080 0 180 $X=838400 $Y=638635
X33360 VSS: 2 VSS: rdata_o[0] 3603 2 BUFX2 $T=852840 13800 0 0 $X=852660 $Y=13535
X33383 VSS: 2 VSS: 4863 4865 2317 2343 4636 2 AOI22X1 $T=862960 30360 1 0 $X=862780 $Y=25915
X33405 VSS: 2 VSS: 4724 4867 4866 4869 4868 2 NAND4X2_HS $T=860200 46920 0 180 $X=854500 $Y=42475
X33418 VSS: 2 VSS: 3465 4834 2 BUFX8_HS $T=859740 55200 1 0 $X=859560 $Y=50755
X33422 VSS: 2 VSS: 4865 7899 2627 4136 2 DFFX1_HS $T=857440 55200 0 0 $X=857260 $Y=54935
X33432 VSS: 2 VSS: 4869 4094 4911 4828 4208 2 AOI22X2_HS $T=865720 63480 1 0 $X=865540 $Y=59035
X33438 VSS: 2 VSS: 4312 4912 2 BUFX16_HS $T=878600 63480 1 180 $X=868300 $Y=63215
X33447 VSS: 2 VSS: 4908 7900 2677 4137 2 DFFX1_HS $T=867100 71760 1 0 $X=866920 $Y=67315
X33454 VSS: 2 VSS: 4910 7901 2627 4137 2 DFFX1_HS $T=868480 71760 0 0 $X=868300 $Y=71495
X33459 VSS: 2 VSS: 4870 3979 2 BUFX16_HS $T=853300 80040 1 0 $X=853120 $Y=75595
X33463 VSS: 2 VSS: 4422 4871 2 BUFX8_HS $T=857440 80040 0 0 $X=857260 $Y=79775
X33472 VSS: 2 VSS: 4871 4500 2 BUFX2 $T=861120 88320 0 180 $X=858640 $Y=83875
X33498 VSS: 2 VSS: 4873 4872 2 INVX8_HS $T=867100 104880 1 0 $X=866920 $Y=100435
X33503 VSS: 2 VSS: 4872 4918 4874 2 NOR2X4_HS $T=871240 104880 1 180 $X=866000 $Y=104615
X33510 VSS: 2 VSS: 4875 4874 2 CLKBUFX2 $T=867560 113160 0 180 $X=865080 $Y=108715
X33515 VSS: 2 VSS: 4116 4876 2 CLKBUFX8 $T=866640 113160 1 180 $X=861400 $Y=112895
X33516 VSS: 2 VSS: 4829 4874 2 BUFX4 $T=869400 113160 1 180 $X=866460 $Y=112895
X33524 VSS: 2 VSS: 4209 4831 4875 2 NOR2X4_HS $T=870320 121440 0 180 $X=865080 $Y=116995
X33527 VSS: 2 VSS: 4877 4209 2 BUFX16_HS $T=869860 121440 1 180 $X=859560 $Y=121175
X33538 VSS: 2 VSS: 4511 4873 2 INVX16_HS $T=867100 129720 1 180 $X=858640 $Y=129455
X33552 VSS: 2 VSS: 4746 2 TIELO $T=863880 138000 0 0 $X=863700 $Y=137735
X33565 VSS: 2 VSS: 3095 4879 2 BUFX2 $T=866640 146280 1 180 $X=864160 $Y=146015
X33650 VSS: 2 VSS: 4880 4791 2 INVX16_HS $T=858820 510600 1 0 $X=858640 $Y=506155
X33654 VSS: 2 VSS: 813 4881 2 BUFX8_HS $T=859740 510600 1 180 $X=854040 $Y=510335
X33655 VSS: 2 VSS: 4838 1641 4744 2 AND2X1_HS $T=862500 510600 1 180 $X=859560 $Y=510335
X33662 VSS: 2 VSS: 4100 4882 2 CLKBUFX8 $T=860660 518880 0 180 $X=855420 $Y=514435
X33667 VSS: 2 VSS: 4125 4928 2 CLKBUFX4 $T=870320 518880 0 180 $X=867380 $Y=514435
X33668 VSS: 2 VSS: 4883 4792 2 INVX16_HS $T=852380 518880 0 0 $X=852200 $Y=518615
X33689 VSS: 2 VSS: 4884 4125 2 CLKBUFX8 $T=868940 535440 0 180 $X=863700 $Y=530995
X33701 VSS: 2 VSS: 4844 7902 2696 4884 2 DFFX1_HS $T=862960 543720 1 0 $X=862780 $Y=539275
X33715 VSS: 2 VSS: 4799 7903 2746 4886 2 DFFX1_HS $T=866180 552000 1 0 $X=866000 $Y=547555
X33718 VSS: 2 VSS: 4888 7904 2746 4887 2 DFFX1_HS $T=855140 552000 0 0 $X=854960 $Y=551735
X33725 VSS: 2 VSS: 4889 7905 2696 4887 2 DFFX1_HS $T=853300 560280 1 0 $X=853120 $Y=555835
X33728 VSS: 2 VSS: 4890 7906 1926 4887 2 DFFX1_HS $T=852380 560280 0 0 $X=852200 $Y=560015
X33739 VSS: 2 VSS: 4846 4888 1991 1990 4798 2 AOI22X1 $T=853760 568560 0 0 $X=853580 $Y=568295
X33755 VSS: 2 VSS: 4931 7907 2746 4893 2 DFFX1_HS $T=865260 576840 0 0 $X=865080 $Y=576575
X33766 VSS: 2 VSS: 4892 4894 4518 4895 4585 2 NAND4X1 $T=861120 585120 1 180 $X=858180 $Y=584855
X33781 VSS: 2 VSS: 4893 4100 2 CLKBUFX8 $T=857900 593400 0 0 $X=857720 $Y=593135
X33783 VSS: 2 VSS: 4809 4897 2320 2558 4896 2 AOI22X1 $T=866180 593400 1 180 $X=863240 $Y=593135
X33792 VSS: 2 VSS: 4935 7908 2696 4893 2 DFFX1_HS $T=864340 601680 1 0 $X=864160 $Y=597235
X33797 VSS: 2 VSS: 4897 7909 2696 4886 2 DFFX1_HS $T=865720 601680 0 0 $X=865540 $Y=601415
X33802 VSS: 2 VSS: 4898 4889 1991 1990 4756 2 AOI22X1 $T=856060 609960 1 0 $X=855880 $Y=605515
X33809 VSS: 2 VSS: 4763 4845 4756 4897 1683 2 AOI22X1 $T=856980 609960 0 0 $X=856800 $Y=609695
X33824 VSS: 2 VSS: 4770 4885 4800 4899 4796 2 AOI22X2_HS $T=862040 618240 1 180 $X=856340 $Y=617975
X33845 VSS: 2 VSS: 4861 4897 4900 2 NAND2X2_HS $T=864800 634800 1 0 $X=864620 $Y=630355
X33849 VSS: 2 VSS: 4900 4885 2 CLKBUFX2 $T=859740 634800 0 0 $X=859560 $Y=634535
X33860 VSS: 2 VSS: 4633 4939 4940 2 NOR2X4_HS $T=868480 643080 1 0 $X=868300 $Y=638635
X33872 VSS: 2 VSS: 4901 3870 4865 4782 3869 2 AOI22X2_HS $T=882740 13800 1 180 $X=877040 $Y=13535
X33881 VSS: 2 VSS: 4902 4422 4782 4865 4816 2 AOI22X1_HS $T=875380 22080 0 0 $X=875200 $Y=21815
X33890 VSS: 2 VSS: 4903 4815 4944 2 CLKAND2X2 $T=885960 30360 0 180 $X=883480 $Y=25915
X33893 VSS: 2 VSS: 4776 4905 4904 4903 2 NAND3X4_HS $T=880440 30360 1 180 $X=873360 $Y=30095
X33898 VSS: 2 VSS: 4904 4906 2 CLKBUFX2_HS $T=872160 38640 1 0 $X=871980 $Y=34195
X33903 VSS: 2 VSS: 4906 4908 4907 4877 4909 2 AOI22X1_HS $T=874460 38640 1 180 $X=871060 $Y=38375
X33915 VSS: 2 VSS: 4867 4221 4907 4908 4047 2 AOI22X1 $T=879520 46920 1 180 $X=876580 $Y=46655
X33939 VSS: 2 VSS: 4136 4948 2 CLKBUFX8 $T=885960 71760 1 180 $X=880720 $Y=71495
X33944 VSS: 2 VSS: 4912 4950 4913 2 NOR2X4_HS $T=887340 80040 0 180 $X=882100 $Y=75595
X33946 VSS: 2 VSS: 4914 4912 2 BUFX16_HS $T=882280 80040 1 180 $X=871980 $Y=79775
X33949 VSS: 2 VSS: 3323 4912 2 CLKBUFX8_HS $T=881820 88320 0 180 $X=872900 $Y=83875
X33952 VSS: 2 VSS: 4787 7910 2627 4138 2 DFFX1_HS $T=870320 88320 0 0 $X=870140 $Y=88055
X33957 VSS: 2 VSS: 4916 4915 4913 2 NOR2X4_HS $T=882740 96600 0 180 $X=877500 $Y=92155
X33963 VSS: 2 VSS: 4915 4917 2 CLKBUFX2_HS $T=883200 96600 1 180 $X=879800 $Y=96335
X33972 VSS: 2 VSS: 4918 4917 2 CLKBUFX2_HS $T=883660 104880 1 180 $X=880260 $Y=104615
X33977 VSS: 2 VSS: 3190 4788 2 BUFX16_HS $T=886420 113160 0 180 $X=876120 $Y=108715
X33981 VSS: 2 VSS: 4831 4953 2 BUFX8 $T=885500 113160 1 180 $X=880260 $Y=112895
X33990 VSS: 2 VSS: 4733 4916 2 BUFX16_HS $T=879520 121440 0 0 $X=879340 $Y=121175
X33992 VSS: 2 VSS: 4735 4919 2 BUFX2 $T=872160 129720 0 180 $X=869680 $Y=125275
X33998 VSS: 2 VSS: 4611 4960 2 BUFX2_HS $T=887340 129720 0 180 $X=884400 $Y=125275
X34000 VSS: 2 VSS: 3496 4916 2 BUFX16_HS $T=884580 129720 1 180 $X=874280 $Y=129455
X34003 VSS: 2 VSS: 4920 4833 2 INVX8_HS $T=870320 138000 1 0 $X=870140 $Y=133555
X34010 VSS: 2 VSS: 4654 4922 2 BUFX2 $T=877220 138000 1 180 $X=874740 $Y=137735
X34013 VSS: 2 VSS: 4647 4921 2 CLKBUFX8 $T=879520 138000 0 0 $X=879340 $Y=137735
X34018 VSS: 2 VSS: 4923 1822 2714 2 NAND2X4_HS $T=877220 146280 1 0 $X=877040 $Y=141835
X34027 VSS: 2 VSS: 4924 3324 2 CLKBUFX8 $T=876760 502320 0 0 $X=876580 $Y=502055
X34029 VSS: 2 VSS: 3324 4925 2 CLKBUFX8 $T=883660 502320 0 0 $X=883480 $Y=502055
X34034 VSS: 2 VSS: 4926 4965 3303 2 NAND2X1 $T=885500 510600 0 180 $X=883480 $Y=506155
X34039 VSS: 2 VSS: 4259 4921 2 CLKBUFX8 $T=879980 510600 0 0 $X=879800 $Y=510335
X34042 VSS: 2 VSS: 4887 4924 2 CLKBUFX2 $T=876760 518880 0 180 $X=874280 $Y=514435
X34043 VSS: 2 VSS: 4927 3990 2 BUFX16_HS $T=886880 518880 0 180 $X=876580 $Y=514435
X34048 VSS: 2 VSS: 4969 3990 2 BUFX16_HS $T=881820 518880 0 0 $X=881640 $Y=518615
X34053 VSS: 2 VSS: 4028 4970 2 CLKBUFX8 $T=886880 527160 0 180 $X=881640 $Y=522715
X34066 VSS: 2 VSS: 4841 8167 2746 135 4884 2 DFFRX1_HS $T=871240 535440 0 0 $X=871060 $Y=535175
X34094 VSS: 2 VSS: 4932 3810 4888 4931 4296 2 AOI22X1_HS $T=882740 560280 1 180 $X=879340 $Y=560015
X34099 VSS: 2 VSS: 4584 4932 4930 4933 4934 2 NAND4X4_HS $T=879060 568560 1 0 $X=878880 $Y=564115
X34103 VSS: 2 VSS: 4934 4617 4805 4856 4929 2 AOI22X2 $T=879060 568560 0 0 $X=878880 $Y=568295
X34115 VSS: 2 VSS: 4894 4931 2013 2012 4856 2 AOI22X1 $T=875380 585120 1 0 $X=875200 $Y=580675
X34145 VSS: 2 VSS: 4850 4935 2013 2012 4857 2 AOI22X1 $T=876300 609960 0 0 $X=876120 $Y=609695
X34151 VSS: 2 VSS: 4678 4936 4768 2 NAND2X4 $T=882280 618240 0 180 $X=877960 $Y=613795
X34158 VSS: 2 VSS: 4937 1683 4899 4800 4845 2 AOI22X2_HS $T=875840 626520 0 180 $X=870140 $Y=622075
X34164 VSS: 2 VSS: 4939 4938 4937 4588 4713 2 NAND4X2_HS $T=877680 626520 1 180 $X=871980 $Y=626255
X34184 VSS: 2 VSS: 4595 4943 4942 4901 4941 2 NAND4X4_HS $T=901600 13800 0 180 $X=892680 $Y=9355
X34202 VSS: 2 VSS: 4559 5000 4999 4998 2 NAND3X4_HS $T=907120 22080 0 180 $X=900040 $Y=17635
X34233 VSS: 2 VSS: 4998 4909 4877 5007 4910 2 AOI22X2_HS $T=904820 38640 0 180 $X=899120 $Y=34195
X34238 VSS: 2 VSS: 4684 7911 2677 3972 2 DFFX1_HS $T=885960 38640 0 0 $X=885780 $Y=38375
X34248 VSS: 2 VSS: 4941 4205 4787 4945 4094 2 AOI22X2_HS $T=901600 46920 0 180 $X=895900 $Y=42475
X34260 VSS: 2 VSS: 4905 4870 4828 4911 4946 2 AOI22X2_HS $T=891020 55200 0 180 $X=885320 $Y=50755
X34271 VSS: 2 VSS: 4909 4206 2 CLKBUFX4 $T=891940 55200 0 0 $X=891760 $Y=54935
X34288 VSS: 2 VSS: 4947 4911 3039 3198 4908 2 AOI22X1 $T=893320 63480 0 0 $X=893140 $Y=63215
X34298 VSS: 2 VSS: 4911 7912 2677 4114 2 DFFX1_HS $T=900220 71760 1 0 $X=900040 $Y=67315
X34305 VSS: 2 VSS: 3980 4949 2 INVX16_HS $T=892400 71760 0 0 $X=892220 $Y=71495
X34318 VSS: 2 VSS: 4949 4951 4952 2 NAND2X4_HS $T=887800 80040 0 0 $X=887620 $Y=79775
X34329 VSS: 2 VSS: 4952 4953 2 INVX4 $T=897000 88320 0 180 $X=894520 $Y=83875
X34339 VSS: 2 VSS: 4954 4917 2 CLKBUFX2_HS $T=892860 88320 0 0 $X=892680 $Y=88055
X34363 VSS: 2 VSS: 4917 4956 4955 2 NAND2X4_HS $T=897460 104880 0 180 $X=892220 $Y=100435
X34372 VSS: 2 VSS: 4955 4957 2 INVX4_HS $T=897000 104880 1 180 $X=893600 $Y=104615
X34383 VSS: 2 VSS: 4958 4956 4959 2 NAND2X4_HS $T=897000 113160 1 0 $X=896820 $Y=108715
X34390 VSS: 2 VSS: 4959 4957 2 INVX4_HS $T=893780 113160 0 0 $X=893600 $Y=112895
X34402 VSS: 2 VSS: 4953 5014 2 BUFX8_HS $T=904820 121440 0 180 $X=899120 $Y=116995
X34409 VSS: 2 VSS: 5015 5014 2 BUFX16_HS $T=908040 121440 1 180 $X=897740 $Y=121175
X34418 VSS: 2 VSS: 4961 4956 2 INVX4_HS $T=897920 129720 1 0 $X=897740 $Y=125275
X34419 VSS: 2 VSS: 5014 4957 4961 2 NAND2X4_HS $T=906200 129720 0 180 $X=900960 $Y=125275
X34426 VSS: 2 VSS: 4956 4962 2 BUFX8_HS $T=899300 129720 1 180 $X=893600 $Y=129455
X34434 VSS: 2 VSS: 2280 4962 2 INVX2 $T=897000 138000 0 180 $X=895440 $Y=133555
X34444 VSS: 2 VSS: 4963 1641 4832 2 AND2X1_HS $T=891480 138000 0 0 $X=891300 $Y=137735
X34445 VSS: 2 VSS: 4962 1364 4963 2 AND2X2_HS $T=894240 138000 0 0 $X=894060 $Y=137735
X34446 VSS: 2 VSS: 5018 4647 2 CLKBUFX8 $T=897460 138000 0 0 $X=897280 $Y=137735
X34460 VSS: 2 VSS: 4964 4923 2 INVX8_HS $T=892400 146280 0 0 $X=892220 $Y=146015
X34617 VSS: 2 VSS: 4297 4966 2 CLKBUFX4 $T=899300 510600 0 180 $X=896360 $Y=506155
X34623 VSS: 2 VSS: 4967 4259 2 CLKBUFX8 $T=886880 510600 0 0 $X=886700 $Y=510335
X34625 VSS: 2 VSS: 1822 4881 2 BUFX8_HS $T=895620 510600 0 0 $X=895440 $Y=510335
X34634 VSS: 2 VSS: 4975 7913 2746 4968 2 DFFX1_HS $T=897000 518880 1 0 $X=896820 $Y=514435
X34638 VSS: 2 VSS: 4968 4297 2 CLKBUFX8 $T=891940 518880 0 0 $X=891760 $Y=518615
X34646 VSS: 2 VSS: 4929 3918 2 BUFX16_HS $T=888260 527160 1 0 $X=888080 $Y=522715
X34653 VSS: 2 VSS: 4971 3918 2 BUFX16_HS $T=888720 527160 0 0 $X=888540 $Y=526895
X34659 VSS: 2 VSS: 4974 4657 4973 4972 3752 2 AOI22X2_HS $T=893780 535440 0 180 $X=888080 $Y=530995
X34679 VSS: 2 VSS: 4976 4569 4975 4841 4127 2 AOI22X1_HS $T=897000 543720 1 0 $X=896820 $Y=539275
X34685 VSS: 2 VSS: 4753 4976 4979 4974 4978 2 NAND4X4_HS $T=886880 543720 0 0 $X=886700 $Y=543455
X34695 VSS: 2 VSS: 4981 3534 4977 4980 3496 2 AOI22X2_HS $T=895160 552000 1 0 $X=894980 $Y=547555
X34701 VSS: 2 VSS: 4979 3540 4982 4842 4705 2 AOI22X1_HS $T=893320 552000 1 180 $X=889920 $Y=551735
X34708 VSS: 2 VSS: 4930 3783 4980 4977 4969 2 AOI22X2 $T=889640 560280 0 180 $X=884860 $Y=555835
X34741 VSS: 2 VSS: 4666 4985 4981 4983 4984 2 NAND4X4_HS $T=896540 576840 0 180 $X=887620 $Y=572395
X34751 VSS: 2 VSS: 4985 4931 4888 4987 4986 2 AOI22X2 $T=898380 576840 1 180 $X=893600 $Y=576575
X34765 VSS: 2 VSS: 4984 4914 4805 4856 4032 2 AOI22X2_HS $T=891480 585120 1 180 $X=885780 $Y=584855
X34775 VSS: 2 VSS: 4624 5027 4990 4989 4988 2 NAND4X4_HS $T=903440 593400 0 180 $X=894520 $Y=588955
X34781 VSS: 2 VSS: 4989 3790 4935 4889 1690 2 AOI22X2 $T=890560 593400 0 0 $X=890380 $Y=593135
X34789 VSS: 2 VSS: 4988 4929 4857 4806 4617 2 AOI22X2 $T=900220 601680 0 180 $X=895440 $Y=597235
X34797 VSS: 2 VSS: 4991 4986 4935 4889 4987 2 AOI22X1 $T=891940 601680 1 180 $X=889000 $Y=601415
X34806 VSS: 2 VSS: 4673 4994 4992 4991 4993 2 NAND4X2_HS $T=895620 609960 1 0 $X=895440 $Y=605515
X34815 VSS: 2 VSS: 4994 4857 4806 4914 4032 2 AOI22X1_HS $T=900680 609960 1 180 $X=897280 $Y=609695
X34824 VSS: 2 VSS: 2864 5029 2 BUFX16_HS $T=908040 618240 0 180 $X=897740 $Y=613795
X34832 VSS: 2 VSS: 4995 4890 1991 1990 4800 2 AOI22X1 $T=891020 618240 0 0 $X=890840 $Y=617975
X34854 VSS: 2 VSS: 4938 4936 4051 2 NAND2X1 $T=885500 634800 1 0 $X=885320 $Y=630355
X34864 VSS: 2 VSS: 4936 7914 1926 4812 2 DFFX1_HS $T=895160 634800 0 0 $X=894980 $Y=634535
X34886 VSS: 2 VSS: 4943 4046 4997 4996 3186 2 AOI22X2_HS $T=906660 13800 0 0 $X=906480 $Y=13535
X34892 VSS: 2 VSS: 4999 4902 5001 2 CLKAND2X2 $T=904820 22080 1 180 $X=902340 $Y=21815
X34898 VSS: 2 VSS: 5001 4996 4997 5002 5003 2 AOI22X1_HS $T=903440 30360 1 0 $X=903260 $Y=25915
X34905 VSS: 2 VSS: 5006 4685 5005 4691 5004 2 NAND4X1 $T=905740 30360 0 0 $X=905560 $Y=30095
X34916 VSS: 2 VSS: 4942 4047 4910 5007 4221 2 AOI22X2 $T=913100 38640 1 180 $X=908320 $Y=38375
X34925 VSS: 2 VSS: 5000 4870 4787 4945 4946 2 AOI22X2_HS $T=910800 46920 1 180 $X=905100 $Y=46655
X34936 VSS: 2 VSS: 5008 4945 3039 3198 4910 2 AOI22X1 $T=913100 55200 0 0 $X=912920 $Y=54935
X34942 VSS: 2 VSS: 4206 5009 2 BUFX16_HS $T=913100 63480 1 0 $X=912920 $Y=59035
X34951 VSS: 2 VSS: 5038 4822 2 BUFX16_HS $T=916320 71760 1 0 $X=916140 $Y=67315
X34956 VSS: 2 VSS: 5009 4954 5039 2 NOR2X4_HS $T=914480 71760 0 0 $X=914300 $Y=71495
X34961 VSS: 2 VSS: 4822 4950 5039 2 NOR2X4_HS $T=913560 80040 1 0 $X=913380 $Y=75595
X34962 VSS: 2 VSS: 4951 4913 2 INVX4 $T=903900 80040 1 180 $X=901420 $Y=79775
X34971 VSS: 2 VSS: 5010 5039 4953 2 NOR2X4_HS $T=920920 88320 0 180 $X=915680 $Y=83875
X34973 VSS: 2 VSS: 3505 5010 2 BUFX8_HS $T=910800 88320 1 180 $X=905100 $Y=88055
X34978 VSS: 2 VSS: 4749 5010 2 BUFX16_HS $T=919080 96600 0 180 $X=908780 $Y=92155
X34983 VSS: 2 VSS: 4948 4659 2 CLKBUFX8 $T=910340 96600 0 0 $X=910160 $Y=96335
X34987 VSS: 2 VSS: 5011 4788 2 BUFX8_HS $T=914480 104880 0 180 $X=908780 $Y=100435
X34991 VSS: 2 VSS: 5012 4957 4956 2 NOR2X4_HS $T=908500 104880 0 0 $X=908320 $Y=104615
X34998 VSS: 2 VSS: 4950 5013 2 BUFX8 $T=911720 113160 1 0 $X=911540 $Y=108715
X35001 VSS: 2 VSS: 5013 4957 4956 2 NAND2X4_HS $T=908040 113160 0 0 $X=907860 $Y=112895
X35008 VSS: 2 VSS: 5045 5013 2 BUFX8_HS $T=922300 121440 0 180 $X=916600 $Y=116995
X35015 VSS: 2 VSS: 5016 4695 2 BUFX16_HS $T=919540 129720 0 180 $X=909240 $Y=125275
X35018 VSS: 2 VSS: 4957 5017 2 BUFX8_HS $T=907120 129720 0 0 $X=906940 $Y=129455
X35023 VSS: 2 VSS: 3151 5017 2 CLKINVX2 $T=909880 138000 0 180 $X=908320 $Y=133555
X35033 VSS: 2 VSS: 5019 1641 4878 2 AND2X1_HS $T=905280 146280 1 0 $X=905100 $Y=141835
X35034 VSS: 2 VSS: 5017 1364 5019 2 AND2X2_HS $T=908040 146280 1 0 $X=907860 $Y=141835
X35035 VSS: 2 VSS: 4133 3852 2 BUFX16_HS $T=921380 146280 0 180 $X=911080 $Y=141835
X35039 VSS: 2 VSS: 3562 4664 2 CLKBUFX8 $T=910800 146280 0 0 $X=910620 $Y=146015
X35043 VSS: 2 VSS: 4921 5020 2 CLKBUFX8 $T=913100 502320 1 180 $X=907860 $Y=502055
X35049 VSS: 2 VSS: 4965 4975 2312 2311 4972 2 AOI22X1 $T=913560 510600 0 180 $X=910620 $Y=506155
X35058 VSS: 2 VSS: 4751 5021 2 CLKBUFX2 $T=913100 518880 0 180 $X=910620 $Y=514435
X35062 VSS: 2 VSS: 5054 4977 4926 2568 2 AOI21X1 $T=916320 518880 1 0 $X=916140 $Y=514435
X35064 VSS: 2 VSS: 4972 7915 2746 4967 2 DFFX1_HS $T=905280 518880 0 0 $X=905100 $Y=518615
X35080 VSS: 2 VSS: 5022 4840 4975 4841 4729 2 AOI22X1_HS $T=904820 535440 1 180 $X=901420 $Y=535175
X35090 VSS: 2 VSS: 4434 7916 2746 4469 2 DFFX1_HS $T=914480 543720 1 0 $X=914300 $Y=539275
X35102 VSS: 2 VSS: 5024 7917 2746 5023 2 DFFX1_HS $T=913560 552000 0 0 $X=913380 $Y=551735
X35107 VSS: 2 VSS: 5028 7918 2696 5023 2 DFFX1_HS $T=913100 560280 1 0 $X=912920 $Y=555835
X35108 VSS: 2 VSS: 4933 3737 4801 5024 4216 2 AOI22X1_HS $T=904820 560280 0 0 $X=904640 $Y=560015
X35118 VSS: 2 VSS: 4847 4982 1695 1716 5024 2 AOI22X1 $T=908500 568560 1 180 $X=905560 $Y=568295
X35133 VSS: 2 VSS: 4983 5025 5024 4801 5026 2 AOI22X2_HS $T=908040 585120 1 0 $X=907860 $Y=580675
X35157 VSS: 2 VSS: 4992 5026 4811 5028 5025 2 AOI22X1 $T=910800 601680 0 0 $X=910620 $Y=601415
X35175 VSS: 2 VSS: 5031 4308 2555 2564 5030 2 AOI22X1 $T=916320 618240 1 180 $X=913380 $Y=617975
X35180 VSS: 2 VSS: 5027 3737 4811 5028 5032 2 AOI22X2_HS $T=913560 626520 0 180 $X=907860 $Y=622075
X35187 VSS: 2 VSS: 5032 4216 2 BUFX2 $T=904360 634800 0 180 $X=901880 $Y=630355
X35192 VSS: 2 VSS: 5030 7919 1926 4813 2 DFFX1_HS $T=914480 634800 1 0 $X=914300 $Y=630355
X35205 VSS: 2 VSS: 4866 3186 5033 5065 4046 2 AOI22X2 $T=936560 13800 0 180 $X=931780 $Y=9355
X35225 VSS: 2 VSS: 5034 4997 2555 2564 4591 2 AOI22X1 $T=924140 22080 0 0 $X=923960 $Y=21815
X35234 VSS: 2 VSS: 4944 5003 5002 5065 5033 2 AOI22X2 $T=936560 30360 0 180 $X=931780 $Y=25915
X35241 VSS: 2 VSS: 5004 5035 3022 3205 4996 2 AOI22X1 $T=927820 30360 0 0 $X=927640 $Y=30095
X35247 VSS: 2 VSS: 4996 7920 2627 4111 2 DFFX1_HS $T=926440 38640 1 0 $X=926260 $Y=34195
X35256 VSS: 2 VSS: 5071 4775 5069 4730 5070 2 NAND4X1 $T=933800 38640 0 0 $X=933620 $Y=38375
X35259 VSS: 2 VSS: 4785 5037 5006 5036 2 NOR3X1 $T=929660 46920 0 180 $X=927180 $Y=42475
X35276 VSS: 2 VSS: 4597 7921 2627 4495 2 DFFX1_HS $T=933800 55200 1 0 $X=933620 $Y=50755
X35292 VSS: 2 VSS: 4945 7922 2627 4114 2 DFFX1_HS $T=922760 63480 0 0 $X=922580 $Y=63215
X35306 VSS: 2 VSS: 5002 5080 2 BUFX2 $T=936100 71760 1 180 $X=933620 $Y=71495
X35317 VSS: 2 VSS: 3852 5040 5039 2 NOR2X4_HS $T=925980 80040 0 0 $X=925800 $Y=79775
X35329 VSS: 2 VSS: 5039 5042 5041 5043 2 NAND3X4_HS $T=925520 88320 0 0 $X=925340 $Y=88055
X35342 VSS: 2 VSS: 4874 4739 5042 5041 2 NAND3X4_HS $T=924140 96600 0 0 $X=923960 $Y=96335
X35345 VSS: 2 VSS: 5040 5012 2 INVX8_HS $T=926900 104880 0 180 $X=921660 $Y=100435
X35348 VSS: 2 VSS: 5082 4874 2 INVX4_HS $T=932420 104880 1 0 $X=932240 $Y=100435
X35354 VSS: 2 VSS: 4788 5044 4874 2 NOR2X4_HS $T=926440 104880 0 0 $X=926260 $Y=104615
X35358 VSS: 2 VSS: 5044 5013 2 CLKBUFX4 $T=925980 113160 1 0 $X=925800 $Y=108715
X35366 VSS: 2 VSS: 4693 5045 5046 2 NOR2X4_HS $T=923220 113160 0 0 $X=923040 $Y=112895
X35377 VSS: 2 VSS: 4695 4950 5047 2 NOR2X4_HS $T=919080 121440 0 0 $X=918900 $Y=121175
X35382 VSS: 2 VSS: 5042 5048 2 BUFX16_HS $T=931500 129720 0 180 $X=921200 $Y=125275
X35392 VSS: 2 VSS: 3154 5048 2 CLKINVX2 $T=926440 129720 1 180 $X=924880 $Y=129455
X35397 VSS: 2 VSS: 5049 1641 4919 2 AND2X1_HS $T=922760 138000 1 0 $X=922580 $Y=133555
X35398 VSS: 2 VSS: 5048 1364 5049 2 AND2X2_HS $T=925520 138000 1 0 $X=925340 $Y=133555
X35406 VSS: 2 VSS: 4739 5050 2 BUFX8_HS $T=928740 138000 1 180 $X=923040 $Y=137735
X35411 VSS: 2 VSS: 5050 1364 5051 2 AND2X1_HS $T=925980 146280 1 0 $X=925800 $Y=141835
X35420 VSS: 2 VSS: 5051 1641 4879 2 AND2X1_HS $T=928740 146280 1 180 $X=925800 $Y=146015
X35423 VSS: 2 VSS: 912 5084 2 BUFX16_HS $T=941160 146280 1 180 $X=930860 $Y=146015
X35495 VSS: 2 VSS: 4659 5052 2 CLKBUFX8 $T=929200 502320 1 180 $X=923960 $Y=502055
X35514 VSS: 2 VSS: 5053 4025 2 CLKBUFX8 $T=937480 518880 0 180 $X=932240 $Y=514435
X35527 VSS: 2 VSS: 4977 7923 2746 5096 2 DFFX1_HS $T=933340 527160 1 0 $X=933160 $Y=522715
X35533 VSS: 2 VSS: 4973 7924 2746 5053 2 DFFX1_HS $T=921840 527160 0 0 $X=921660 $Y=526895
X35548 VSS: 2 VSS: 4433 7925 2746 5098 2 DFFX1_HS $T=933800 535440 0 0 $X=933620 $Y=535175
X35595 VSS: 2 VSS: 4895 5055 2006 2007 4980 2 AOI22X1 $T=924600 568560 0 0 $X=924420 $Y=568295
X35602 VSS: 2 VSS: 4980 7926 2746 5056 2 DFFX1_HS $T=928740 576840 1 0 $X=928560 $Y=572395
X35610 VSS: 2 VSS: 5057 7927 2696 5056 2 DFFX1_HS $T=929200 576840 0 0 $X=929020 $Y=576575
X35619 VSS: 2 VSS: 4993 3534 4733 5057 5058 2 AOI22X2 $T=929200 585120 1 180 $X=924420 $Y=584855
X35633 VSS: 2 VSS: 4990 3497 5057 5058 4969 2 AOI22X2 $T=931960 593400 1 180 $X=927180 $Y=593135
X35638 VSS: 2 VSS: 4855 5059 1695 1716 5028 2 AOI22X1 $T=925060 601680 1 0 $X=924880 $Y=597235
X35658 VSS: 2 VSS: 5062 4936 1701 1726 5061 2 AOI22X1 $T=923220 609960 1 180 $X=920280 $Y=609695
X35664 VSS: 2 VSS: 5063 5060 4995 4476 5062 2 NAND4X1 $T=920460 618240 1 0 $X=920280 $Y=613795
X35676 VSS: 2 VSS: 5112 5114 4449 5115 4631 2 NAND4X1 $T=936560 618240 1 180 $X=933620 $Y=617975
X35687 VSS: 2 VSS: 5116 7194 2945 4813 2 DFFX4_HS $T=929200 626520 0 0 $X=929020 $Y=626255
X35692 VSS: 2 VSS: 5029 5117 5064 2 NAND2X4_HS $T=935640 634800 0 180 $X=930400 $Y=630355
X35703 VSS: 2 VSS: 1676 4885 2 BUFX16_HS $T=923220 643080 1 0 $X=923040 $Y=638635
X35722 VSS: 2 VSS: 5037 4863 5067 5034 5066 2 NAND4X1 $T=934260 22080 1 0 $X=934080 $Y=17635
X35731 VSS: 2 VSS: 5068 5065 2555 2564 4684 2 AOI22X1 $T=947140 22080 0 0 $X=946960 $Y=21815
X35745 VSS: 2 VSS: 5070 5124 3022 3205 5033 2 AOI22X1 $T=949440 30360 0 0 $X=949260 $Y=30095
X35755 VSS: 2 VSS: 5033 7928 2677 4111 2 DFFX1_HS $T=949900 38640 1 0 $X=949720 $Y=34195
X35767 VSS: 2 VSS: 5066 5072 2320 2558 4597 2 AOI22X1 $T=948520 46920 1 0 $X=948340 $Y=42475
X35769 VSS: 2 VSS: 4825 5073 5071 5074 2 NOR3X1 $T=939320 46920 1 180 $X=936840 $Y=46655
X35781 VSS: 2 VSS: 5036 4642 5075 5008 5076 2 NAND4X1 $T=934720 55200 0 0 $X=934540 $Y=54935
X35794 VSS: 2 VSS: 5074 4689 5078 4947 5077 2 NAND4X1 $T=947140 63480 1 0 $X=946960 $Y=59035
X35805 VSS: 2 VSS: 5077 5079 1701 1726 4424 2 AOI22X1 $T=941160 71760 1 0 $X=940980 $Y=67315
X35811 VSS: 2 VSS: 4367 4423 2 BUFX16_HS $T=947140 71760 0 0 $X=946960 $Y=71495
X35815 VSS: 2 VSS: 5080 3852 2 BUFX4_HS $T=934260 80040 1 0 $X=934080 $Y=75595
X35818 VSS: 2 VSS: 4423 5131 2 BUFX16_HS $T=952200 80040 0 180 $X=941900 $Y=75595
X35821 VSS: 2 VSS: 4114 5081 2 CLKBUFX8 $T=942080 80040 1 180 $X=936840 $Y=79775
X35834 VSS: 2 VSS: 5131 5040 4913 2 NOR2X4_HS $T=949900 88320 1 0 $X=949720 $Y=83875
X35844 VSS: 2 VSS: 5043 4739 2 INVX4_HS $T=940240 96600 0 180 $X=936840 $Y=92155
X35849 VSS: 2 VSS: 5133 4739 2 INVX4_HS $T=953120 96600 0 180 $X=949720 $Y=92155
X35862 VSS: 2 VSS: 5041 5083 2 INVX8_HS $T=942080 104880 1 0 $X=941900 $Y=100435
X35865 VSS: 2 VSS: 4913 5133 5083 5135 2 NAND3X4_HS $T=949900 104880 1 0 $X=949720 $Y=100435
X35868 VSS: 2 VSS: 5003 5011 2 BUFX16_HS $T=939320 104880 0 0 $X=939140 $Y=104615
X35878 VSS: 2 VSS: 4454 5084 2 BUFX4_HS $T=935180 113160 0 0 $X=935000 $Y=112895
X35881 VSS: 2 VSS: 5139 5013 2 BUFX8_HS $T=946220 113160 0 0 $X=946040 $Y=112895
X35885 VSS: 2 VSS: 5084 5015 5086 2 NOR2X4_HS $T=934260 121440 1 0 $X=934080 $Y=116995
X35891 VSS: 2 VSS: 5047 5085 5042 2 OR2X1_HS $T=938400 121440 1 180 $X=935460 $Y=121175
X35894 VSS: 2 VSS: 5086 5085 5042 2 OR2X2_HS $T=947140 121440 1 180 $X=943740 $Y=121175
X35900 VSS: 2 VSS: 4960 5040 5086 2 NOR2X4_HS $T=934720 129720 1 0 $X=934540 $Y=125275
X35904 VSS: 2 VSS: 5085 4739 5083 2 NAND2X4_HS $T=946220 129720 1 0 $X=946040 $Y=125275
X35907 VSS: 2 VSS: 5083 5087 2 BUFX8_HS $T=947600 129720 1 180 $X=941900 $Y=129455
X35915 VSS: 2 VSS: 3145 5087 2 CLKINVX2 $T=945300 138000 0 180 $X=943740 $Y=133555
X35921 VSS: 2 VSS: 5088 1641 4922 2 AND2X1_HS $T=941620 138000 0 0 $X=941440 $Y=137735
X35922 VSS: 2 VSS: 5087 1364 5088 2 AND2X2_HS $T=944380 138000 0 0 $X=944200 $Y=137735
X35927 VSS: 2 VSS: 4329 5089 2 CLKBUFX8 $T=939320 146280 0 180 $X=934080 $Y=141835
X35931 VSS: 2 VSS: 4796 4834 2 BUFX16_HS $T=942540 146280 1 0 $X=942360 $Y=141835
X36013 VSS: 2 VSS: 5090 4659 2 CLKBUFX8 $T=943460 502320 0 0 $X=943280 $Y=502055
X36021 VSS: 2 VSS: 5091 1822 2466 2 NAND2X4_HS $T=942080 510600 1 0 $X=941900 $Y=506155
X36024 VSS: 2 VSS: 4842 7929 2746 5092 2 DFFX1_HS $T=936100 510600 0 0 $X=935920 $Y=510335
X36030 VSS: 2 VSS: 4896 7930 2696 5092 2 DFFX1_HS $T=937480 518880 1 0 $X=937300 $Y=514435
X36031 VSS: 2 VSS: 4025 5148 2 CLKBUFX8 $T=951740 518880 0 180 $X=946500 $Y=514435
X36033 VSS: 2 VSS: rdata_o[3] 5094 5054 5093 4891 2 NAND4X2 $T=939780 518880 1 180 $X=935000 $Y=518615
X36047 VSS: 2 VSS: 5094 4433 2991 2992 4973 2 AOI22X1 $T=944380 527160 0 0 $X=944200 $Y=526895
X36054 VSS: 2 VSS: 5097 5016 4973 4972 3620 2 AOI22X2_HS $T=938400 535440 1 0 $X=938220 $Y=530995
X36058 VSS: 2 VSS: 4067 5150 2 CLKBUFX8 $T=952200 535440 0 180 $X=946960 $Y=530995
X36068 VSS: 2 VSS: 5098 4406 2 CLKBUFX8 $T=947140 543720 0 180 $X=941900 $Y=539275
X36069 VSS: 2 VSS: 3687 5144 2 BUFX16_HS $T=957260 543720 0 180 $X=946960 $Y=539275
X36072 VSS: 2 VSS: 5093 4434 2785 2796 5099 2 AOI22X1 $T=938400 543720 1 180 $X=935460 $Y=543455
X36082 VSS: 2 VSS: 4706 5022 5101 5100 5097 2 NAND4X4_HS $T=940240 552000 1 0 $X=940060 $Y=547555
X36085 VSS: 2 VSS: 5055 7931 2746 5102 2 DFFX1_HS $T=936100 552000 0 0 $X=935920 $Y=551735
X36093 VSS: 2 VSS: 5101 5104 4842 4982 5103 2 AOI22X2 $T=947140 560280 0 180 $X=942360 $Y=555835
X36095 VSS: 2 VSS: 4978 3541 5055 5099 3313 2 AOI22X2_HS $T=939780 560280 1 180 $X=934080 $Y=560015
X36104 VSS: 2 VSS: 5059 7932 2696 5105 2 DFFX1_HS $T=937020 568560 1 0 $X=936840 $Y=564115
X36109 VSS: 2 VSS: 4982 7933 2746 5105 2 DFFX1_HS $T=939320 568560 0 0 $X=939140 $Y=568295
X36130 VSS: 2 VSS: 4849 5106 2006 2007 5057 2 AOI22X1 $T=945300 585120 1 0 $X=945120 $Y=580675
X36156 VSS: 2 VSS: 5108 4304 2317 2319 5107 2 AOI22X1 $T=948520 601680 0 180 $X=945580 $Y=597235
X36166 VSS: 2 VSS: 5110 4899 2320 2558 5109 2 AOI22X1 $T=937020 609960 0 180 $X=934080 $Y=605515
X36182 VSS: 2 VSS: 5111 5113 5112 5063 2 NOR3X1 $T=942540 618240 1 0 $X=942360 $Y=613795
X36197 VSS: 2 VSS: 5113 5108 4680 5031 5110 2 NAND4X1 $T=945300 626520 0 180 $X=942360 $Y=622075
X36210 VSS: 2 VSS: 5118 4522 2 BUFX2 $T=947600 634800 1 0 $X=947420 $Y=630355
X36214 VSS: 2 VSS: 5117 5119 4589 2 NOR2X4_HS $T=942080 634800 1 180 $X=936840 $Y=634535
X36233 VSS: 2 VSS: 5122 5121 5120 2 AND2X1_HS $T=964160 13800 0 180 $X=961220 $Y=9355
X36241 VSS: 2 VSS: 4526 5123 5122 2 NAND2X4_HS $T=960020 13800 1 180 $X=954780 $Y=13535
X36275 VSS: 2 VSS: 5073 4820 5125 5068 5126 2 NAND4X1 $T=953120 38640 0 0 $X=952940 $Y=38375
X36290 VSS: 2 VSS: 5126 5127 2320 2558 4602 2 AOI22X1 $T=955420 46920 0 0 $X=955240 $Y=46655
X36303 VSS: 2 VSS: 4602 7934 2677 4495 2 DFFX1_HS $T=954960 55200 0 0 $X=954780 $Y=54935
X36315 VSS: 2 VSS: 5076 5128 1701 1726 4497 2 AOI22X1 $T=960020 63480 0 0 $X=959840 $Y=63215
X36320 VSS: 2 VSS: 4946 3980 2 BUFX16_HS $T=955880 71760 1 0 $X=955700 $Y=67315
X36328 VSS: 2 VSS: 4495 5129 2 CLKBUFX4 $T=966460 71760 1 180 $X=963520 $Y=71495
X36332 VSS: 2 VSS: 5130 4454 2 BUFX16_HS $T=956800 80040 1 0 $X=956620 $Y=75595
X36337 VSS: 2 VSS: 1206 5132 2 BUFX16_HS $T=961860 80040 1 180 $X=951560 $Y=79775
X36340 VSS: 2 VSS: 5162 4051 2 BUFX16_HS $T=964620 80040 0 0 $X=964440 $Y=79775
X36350 VSS: 2 VSS: 3534 5131 2 BUFX16_HS $T=951740 88320 0 0 $X=951560 $Y=88055
X36356 VSS: 2 VSS: 5134 4739 2 INVX4_HS $T=959560 96600 1 0 $X=959380 $Y=92155
X36375 VSS: 2 VSS: 5136 5083 5042 5134 2 NAND3X4_HS $T=969220 104880 1 180 $X=962140 $Y=104615
X36377 VSS: 2 VSS: 5135 5042 2 INVX4_HS $T=951740 113160 1 0 $X=951560 $Y=108715
X36388 VSS: 2 VSS: 136 5137 2 CLKBUFX8 $T=962780 113160 1 180 $X=957540 $Y=112895
X36389 VSS: 2 VSS: 5138 5135 5085 2 NOR2X1_HS $T=962780 113160 0 0 $X=962600 $Y=112895
X36390 VSS: 2 VSS: 5140 5138 2 INVX2_HS $T=965080 113160 0 0 $X=964900 $Y=112895
X36391 VSS: 2 VSS: 5046 5085 5135 2 OR2X2_HS $T=952200 121440 1 0 $X=952020 $Y=116995
X36401 VSS: 2 VSS: 5141 5045 5046 2 NOR2X4_HS $T=960020 121440 1 180 $X=954780 $Y=121175
X36407 VSS: 2 VSS: 5142 5085 5042 2 OR2X1 $T=960480 129720 1 0 $X=960300 $Y=125275
X36416 VSS: 2 VSS: 5143 5045 5136 2 NOR2X4_HS $T=955880 129720 0 0 $X=955700 $Y=129455
X36420 VSS: 2 VSS: 5144 4960 2 BUFX16_HS $T=951280 138000 1 0 $X=951100 $Y=133555
X36423 VSS: 2 VSS: 5180 4960 2 CLKINVX4 $T=965540 138000 1 0 $X=965360 $Y=133555
X36432 VSS: 2 VSS: 4729 5143 2 BUFX16_HS $T=952660 146280 1 0 $X=952480 $Y=141835
X36433 VSS: 2 VSS: 5103 5084 2 BUFX16_HS $T=962780 146280 1 0 $X=962600 $Y=141835
X36515 VSS: 2 VSS: 4337 5146 2 CLKBUFX8 $T=966920 502320 1 180 $X=961680 $Y=502055
X36525 VSS: 2 VSS: 5145 3980 2 BUFX8_HS $T=956340 510600 0 0 $X=956160 $Y=510335
X36533 VSS: 2 VSS: 5184 5058 5147 2568 2 AOI21X1 $T=965080 518880 1 0 $X=964900 $Y=514435
X36544 VSS: 2 VSS: 5058 7935 2696 5096 2 DFFX1_HS $T=954960 527160 1 0 $X=954780 $Y=522715
X36555 VSS: 2 VSS: 4440 7936 2696 5098 2 DFFX1_HS $T=964160 527160 0 0 $X=963980 $Y=526895
X36557 VSS: 2 VSS: 4406 5149 2 CLKBUFX4 $T=958640 535440 0 180 $X=955700 $Y=530995
X36576 VSS: 2 VSS: 4438 7937 2696 4469 2 DFFX1_HS $T=960480 543720 0 0 $X=960300 $Y=543455
X36606 VSS: 2 VSS: 5191 3491 5182 4844 4127 2 AOI22X1 $T=968760 568560 0 180 $X=965820 $Y=564115
X36616 VSS: 2 VSS: 5192 5191 5153 2 AND2X1_HS $T=966000 568560 0 0 $X=965820 $Y=568295
X36620 VSS: 2 VSS: 5153 3540 5059 4896 4705 2 AOI22X1 $T=958640 576840 0 180 $X=955700 $Y=572395
X36635 VSS: 2 VSS: 5154 5152 2 CLKBUFX2_HS $T=969680 585120 0 180 $X=966280 $Y=580675
X36643 VSS: 2 VSS: 4709 5154 5151 5194 5155 2 NAND4X4_HS $T=964160 585120 0 0 $X=963980 $Y=584855
X36646 VSS: 2 VSS: 5155 5103 5059 4896 5104 2 AOI22X2 $T=954040 593400 1 0 $X=953860 $Y=588955
X36661 VSS: 2 VSS: 5157 7938 1926 4893 2 DFFX1_HS $T=963700 601680 1 0 $X=963520 $Y=597235
X36666 VSS: 2 VSS: 4899 7939 1926 4886 2 DFFX1_HS $T=955880 601680 0 0 $X=955700 $Y=601415
X36672 VSS: 2 VSS: 5158 5157 4890 4987 4986 2 AOI22X2 $T=966460 609960 0 180 $X=961680 $Y=605515
X36680 VSS: 2 VSS: 4626 5158 5156 5159 2 NAND3X4_HS $T=960940 609960 1 180 $X=953860 $Y=609695
X36686 VSS: 2 VSS: 5114 5157 2013 2012 4858 2 AOI22X1 $T=966000 618240 0 180 $X=963060 $Y=613795
X36695 VSS: 2 VSS: 5160 1690 4890 5157 4296 2 AOI22X2_HS $T=966920 618240 1 180 $X=961220 $Y=617975
X36750 VSS: 2 VSS: 5120 5128 5162 2 NAND2X4_HS $T=976580 22080 1 180 $X=971340 $Y=21815
X36763 VSS: 2 VSS: 5164 3828 5163 5035 4336 2 AOI22X2_HS $T=976120 30360 0 0 $X=975940 $Y=30095
X36768 VSS: 2 VSS: 5123 5164 5165 2 AND2X2_HS $T=973360 38640 0 180 $X=969960 $Y=34195
X36776 VSS: 2 VSS: 5165 3461 5072 5166 4179 2 AOI22X2_HS $T=982560 38640 1 180 $X=976860 $Y=38375
X36782 VSS: 2 VSS: 5005 5161 3028 3029 5007 2 AOI22X1 $T=971520 46920 1 0 $X=971340 $Y=42475
X36786 VSS: 2 VSS: 3972 5167 2 CLKBUFX8 $T=974280 46920 1 180 $X=969040 $Y=46655
X36788 VSS: 2 VSS: 5069 5168 3028 3029 4907 2 AOI22X1 $T=975200 46920 0 0 $X=975020 $Y=46655
X36803 VSS: 2 VSS: 5078 4773 1991 1990 5205 2 AOI22X1 $T=984400 55200 1 180 $X=981460 $Y=54935
X36812 VSS: 2 VSS: 5075 4560 1991 1990 5166 2 AOI22X1 $T=983020 63480 0 180 $X=980080 $Y=59035
X36818 VSS: 2 VSS: 5171 3508 3501 5204 5168 2 AOI22X1_HS $T=983020 63480 0 0 $X=982840 $Y=63215
X36826 VSS: 2 VSS: 4780 5169 5170 2 NAND2X4_HS $T=984400 71760 0 180 $X=979160 $Y=67315
X36827 VSS: 2 VSS: 5172 5079 5162 2 NAND2X1 $T=968300 71760 0 0 $X=968120 $Y=71495
X36833 VSS: 2 VSS: 5170 5171 5172 2 AND2X2_HS $T=980720 71760 0 0 $X=980540 $Y=71495
X36841 VSS: 2 VSS: 5173 5080 2 BUFX2 $T=975660 80040 1 0 $X=975480 $Y=75595
X36846 VSS: 2 VSS: 3971 5209 2 CLKBUFX8 $T=987160 80040 1 180 $X=981920 $Y=79775
X36851 VSS: 2 VSS: 5174 4739 2 INVX4_HS $T=973360 88320 1 0 $X=973180 $Y=83875
X36857 VSS: 2 VSS: 4500 5040 5175 2 NOR2X4_HS $T=977500 88320 1 180 $X=972260 $Y=88055
X36864 VSS: 2 VSS: 5178 5174 5176 2 NAND2X4_HS $T=969220 96600 1 0 $X=969040 $Y=92155
X36865 VSS: 2 VSS: 3356 5177 2 BUFX16_HS $T=984400 96600 0 180 $X=974100 $Y=92155
X36870 VSS: 2 VSS: 5175 5176 4739 2 NAND2X4_HS $T=971060 96600 0 0 $X=970880 $Y=96335
X36878 VSS: 2 VSS: 5176 5083 5042 2 NOR2X4_HS $T=970600 104880 1 0 $X=970420 $Y=100435
X36882 VSS: 2 VSS: 4138 5214 2 CLKBUFX8 $T=986700 104880 0 180 $X=981460 $Y=100435
X36892 VSS: 2 VSS: 4426 4958 5178 2 NOR2X4_HS $T=978880 113160 0 180 $X=973640 $Y=108715
X36903 VSS: 2 VSS: 4834 5015 5178 2 NOR2X4_HS $T=970140 121440 1 0 $X=969960 $Y=116995
X36910 VSS: 2 VSS: 4082 5175 5015 2 NOR2X4_HS $T=978880 121440 1 180 $X=973640 $Y=121175
X36918 VSS: 2 VSS: 5179 5015 5140 2 NOR2X4_HS $T=974280 129720 1 0 $X=974100 $Y=125275
X36924 VSS: 2 VSS: 4781 5136 5015 2 NOR2X4_HS $T=979800 129720 1 180 $X=974560 $Y=129455
X36931 VSS: 2 VSS: 4501 5179 2 BUFX8_HS $T=973360 138000 1 0 $X=973180 $Y=133555
X36937 VSS: 2 VSS: 5190 5179 2 BUFX16_HS $T=975200 138000 0 0 $X=975020 $Y=137735
X36941 VSS: 2 VSS: 704 5179 2 BUFX16_HS $T=972900 146280 1 0 $X=972720 $Y=141835
X36948 VSS: 2 VSS: 1686 5221 2 BUFX16_HS $T=982100 146280 0 0 $X=981920 $Y=146015
X37032 VSS: 2 VSS: 5147 5181 3310 2 NAND2X1 $T=974740 510600 0 180 $X=972720 $Y=506155
X37039 VSS: 2 VSS: 5181 5182 2312 2311 5183 2 AOI22X1 $T=983020 510600 1 180 $X=980080 $Y=510335
X37048 VSS: 2 VSS: 5182 7940 2696 4968 2 DFFX1_HS $T=977500 518880 1 0 $X=977320 $Y=514435
X37052 VSS: 2 VSS: rdata_o[7] 5187 5184 5186 4854 2 NAND4X2 $T=978880 518880 1 180 $X=974100 $Y=518615
X37062 VSS: 2 VSS: 5187 4440 2991 2992 5188 2 AOI22X1 $T=979340 527160 1 0 $X=979160 $Y=522715
X37072 VSS: 2 VSS: 5151 5016 5188 5183 3620 2 AOI22X2 $T=978880 535440 0 180 $X=974100 $Y=530995
X37076 VSS: 2 VSS: 5186 4438 2785 2796 5189 2 AOI22X1 $T=973360 535440 1 180 $X=970420 $Y=535175
X37104 VSS: 2 VSS: 5100 5190 5055 5099 5144 2 AOI22X2_HS $T=977960 552000 1 180 $X=972260 $Y=551735
X37113 VSS: 2 VSS: 5106 7941 2696 5102 2 DFFX1_HS $T=977500 560280 1 0 $X=977320 $Y=555835
X37114 VSS: 2 VSS: 5152 4840 5182 4844 4729 2 AOI22X1_HS $T=972440 560280 1 180 $X=969040 $Y=560015
X37136 VSS: 2 VSS: 5194 5144 5189 5106 5190 2 AOI22X1_HS $T=983020 576840 0 180 $X=979620 $Y=572395
X37142 VSS: 2 VSS: 4761 5192 5193 2 NAND2X4_HS $T=971060 576840 0 0 $X=970880 $Y=576575
X37163 VSS: 2 VSS: 5156 4858 5107 4914 4032 2 AOI22X2 $T=973820 593400 1 180 $X=969040 $Y=593135
X37206 VSS: 2 VSS: 1775 5195 2 BUFX16_HS $T=967840 626520 1 0 $X=967660 $Y=622075
X37210 VSS: 2 VSS: 5195 5196 5197 2 NAND2X2_HS $T=971980 626520 0 0 $X=971800 $Y=626255
X37219 VSS: 2 VSS: 5196 4270 5198 2 NOR2X4_HS $T=970600 634800 1 0 $X=970420 $Y=630355
X37231 VSS: 2 VSS: 5199 4051 2 INVX8_HS $T=967380 643080 1 0 $X=967200 $Y=638635
X37244 VSS: 2 VSS: 4481 5200 5241 5240 5239 2 NAND4X4_HS $T=996820 13800 1 0 $X=996640 $Y=9355
X37250 VSS: 2 VSS: 5241 3500 5161 5201 3505 2 AOI22X2_HS $T=998200 13800 0 0 $X=998020 $Y=13535
X37252 VSS: 2 VSS: 5121 5161 5201 3501 3508 2 AOI22X2_HS $T=984400 22080 1 0 $X=984220 $Y=17635
X37263 VSS: 2 VSS: 4997 7942 2627 5202 2 DFFX1_HS $T=986700 30360 1 0 $X=986520 $Y=25915
X37272 VSS: 2 VSS: 5067 5201 3183 2808 5163 2 AOI22X1 $T=988540 38640 1 0 $X=988360 $Y=34195
X37283 VSS: 2 VSS: 5125 5204 2606 2808 5203 2 AOI22X1 $T=996360 46920 0 180 $X=993420 $Y=42475
X37291 VSS: 2 VSS: 5206 3461 5127 5205 4179 2 AOI22X1_HS $T=990840 55200 1 0 $X=990660 $Y=50755
X37303 VSS: 2 VSS: 5169 5244 5206 2 AND2X1_HS $T=998200 63480 1 0 $X=998020 $Y=59035
X37320 VSS: 2 VSS: 5207 5173 2 BUFX4_HS $T=989920 80040 1 0 $X=989740 $Y=75595
X37323 VSS: 2 VSS: 5208 5080 2 BUFX16_HS $T=987160 80040 0 0 $X=986980 $Y=79775
X37327 VSS: 2 VSS: 5210 5132 2 BUFX2_HS $T=991300 88320 1 0 $X=991120 $Y=83875
X37332 VSS: 2 VSS: 3432 5211 2 BUFX8_HS $T=993140 88320 1 180 $X=987440 $Y=88055
X37342 VSS: 2 VSS: 5212 5139 5178 2 NOR2X4_HS $T=991300 96600 1 180 $X=986060 $Y=96335
X37345 VSS: 2 VSS: 5213 5040 2 INVX4_HS $T=999120 96600 1 180 $X=995720 $Y=96335
X37350 VSS: 2 VSS: 5215 5213 5082 2 NAND2X4_HS $T=994980 104880 1 0 $X=994800 $Y=100435
X37351 VSS: 2 VSS: 3867 4958 5136 2 NOR2X4_HS $T=989000 104880 1 180 $X=983760 $Y=104615
X37357 VSS: 2 VSS: 5132 4958 5140 2 NOR2X4_HS $T=989000 113160 1 0 $X=988820 $Y=108715
X37360 VSS: 2 VSS: 5253 5132 2 BUFX8_HS $T=998200 113160 1 0 $X=998020 $Y=108715
X37363 VSS: 2 VSS: 5216 4958 5175 2 NOR2X4_HS $T=992220 113160 1 180 $X=986980 $Y=112895
X37368 VSS: 2 VSS: 5217 5139 5175 2 NOR2X4_HS $T=994980 121440 0 180 $X=989740 $Y=116995
X37373 VSS: 2 VSS: 5218 5142 4958 2 NOR2X2_HS $T=996820 121440 1 180 $X=993420 $Y=121175
X37377 VSS: 2 VSS: 5219 5040 5140 2 NOR2X4_HS $T=999120 129720 0 180 $X=993880 $Y=125275
X37381 VSS: 2 VSS: 3620 5218 2 BUFX16_HS $T=1000960 129720 1 180 $X=990660 $Y=129455
X37382 VSS: 2 VSS: 5220 5040 5136 2 NOR2X4_HS $T=989460 138000 0 180 $X=984220 $Y=133555
X37384 VSS: 2 VSS: 3721 5220 2 BUFX8_HS $T=993140 138000 1 0 $X=992960 $Y=133555
X37391 VSS: 2 VSS: 4885 5217 2 BUFX16_HS $T=995900 138000 0 0 $X=995720 $Y=137735
X37394 VSS: 2 VSS: 5221 5220 2 CLKBUFX2_HS $T=989460 146280 0 180 $X=986060 $Y=141835
X37399 VSS: 2 VSS: 4986 5220 2 BUFX16_HS $T=998200 146280 1 0 $X=998020 $Y=141835
X37404 VSS: 2 VSS: 5081 5222 2 CLKBUFX4 $T=988540 502320 1 180 $X=985600 $Y=502055
X37407 VSS: 2 VSS: 5258 5091 2 CLKINVX8_HS $T=993140 502320 0 0 $X=992960 $Y=502055
X37412 VSS: 2 VSS: 4128 5222 2 CLKBUFX8 $T=999580 510600 0 180 $X=994340 $Y=506155
X37420 VSS: 2 VSS: 5183 7943 2696 4967 2 DFFX1_HS $T=989460 518880 1 0 $X=989280 $Y=514435
X37432 VSS: 2 VSS: 5188 7944 2696 5053 2 DFFX1_HS $T=985780 527160 0 0 $X=985600 $Y=526895
X37439 VSS: 2 VSS: 5223 2997 5183 5188 4657 2 AOI22X2 $T=1000500 535440 0 180 $X=995720 $Y=530995
X37446 VSS: 2 VSS: 4410 7945 1926 4469 2 DFFX1_HS $T=985320 543720 1 0 $X=985140 $Y=539275
X37451 VSS: 2 VSS: 5099 7946 2746 5224 2 DFFX1_HS $T=989920 543720 0 0 $X=989740 $Y=543455
X37454 VSS: 2 VSS: 5189 7947 2696 5224 2 DFFX1_HS $T=989460 552000 1 0 $X=989280 $Y=547555
X37467 VSS: 2 VSS: 5225 3313 2 BUFX2_HS $T=991760 560280 0 0 $X=991580 $Y=560015
X37474 VSS: 2 VSS: 5226 3541 5106 5189 5225 2 AOI22X2_HS $T=994980 568560 1 0 $X=994800 $Y=564115
X37479 VSS: 2 VSS: 5193 5223 5226 2 AND2X1_HS $T=996360 568560 1 180 $X=993420 $Y=568295
X37492 VSS: 2 VSS: 5107 7948 1926 4759 2 DFFX1_HS $T=988540 585120 1 0 $X=988360 $Y=580675
X37502 VSS: 2 VSS: 5229 3534 4733 5227 5228 2 AOI22X2_HS $T=995900 593400 0 180 $X=990200 $Y=588955
X37515 VSS: 2 VSS: 5230 4374 5227 5228 4969 2 AOI22X2_HS $T=1001880 601680 0 180 $X=996180 $Y=597235
X37525 VSS: 2 VSS: 5159 5232 5229 2 AND2X2_HS $T=993600 609960 1 0 $X=993420 $Y=605515
X37529 VSS: 2 VSS: 5233 4617 5107 4858 4971 2 AOI22X2_HS $T=991300 609960 0 0 $X=991120 $Y=609695
X37534 VSS: 2 VSS: 5232 5025 5231 5030 5026 2 AOI22X2_HS $T=993600 618240 1 0 $X=993420 $Y=613795
X37540 VSS: 2 VSS: 4635 5234 5160 5230 5233 2 NAND4X4_HS $T=995440 618240 0 0 $X=995260 $Y=617975
X37548 VSS: 2 VSS: 5234 3859 5030 5231 4216 2 AOI22X1_HS $T=1000500 626520 1 180 $X=997100 $Y=626255
X37552 VSS: 2 VSS: 2665 5235 2 BUFX16_HS $T=992680 634800 1 0 $X=992500 $Y=630355
X37557 VSS: 2 VSS: 5235 5237 5236 2 NAND2X2_HS $T=995900 634800 0 0 $X=995720 $Y=634535
X37563 VSS: 2 VSS: 5237 4388 5238 2 NOR2X4_HS $T=994980 643080 1 0 $X=994800 $Y=638635
X37586 VSS: 2 VSS: 5200 5128 5242 2 NAND2X2 $T=1009700 22080 1 180 $X=1007220 $Y=21815
X37602 VSS: 2 VSS: 5065 7949 2677 5202 2 DFFX1_HS $T=1014300 30360 0 0 $X=1014120 $Y=30095
X37613 VSS: 2 VSS: 5239 5243 5072 5166 3466 2 AOI22X2_HS $T=1012000 38640 0 0 $X=1011820 $Y=38375
X37619 VSS: 2 VSS: 5243 4834 2 CLKBUFX2 $T=1013380 46920 1 0 $X=1013200 $Y=42475
X37626 VSS: 2 VSS: 5244 4336 5124 5203 3828 2 AOI22X1_HS $T=1004180 46920 1 180 $X=1000780 $Y=46655
X37653 VSS: 2 VSS: 4821 5247 5245 2 NAND2X4_HS $T=1005100 63480 0 0 $X=1004920 $Y=63215
X37656 VSS: 2 VSS: 5247 5250 5248 2 AND2X1_HS $T=1002800 71760 1 0 $X=1002620 $Y=67315
X37661 VSS: 2 VSS: 3466 5249 2 INVX16_HS $T=1015220 71760 1 0 $X=1015040 $Y=67315
X37666 VSS: 2 VSS: 5248 3500 5168 5204 3505 2 AOI22X2_HS $T=1001420 71760 0 0 $X=1001240 $Y=71495
X37673 VSS: 2 VSS: 5250 5079 5210 2 NAND2X1 $T=1004180 80040 1 0 $X=1004000 $Y=75595
X37687 VSS: 2 VSS: 5251 5211 2 BUFX16_HS $T=1004180 88320 1 0 $X=1004000 $Y=83875
X37698 VSS: 2 VSS: 5211 5219 2 BUFX2_HS $T=1000960 96600 1 0 $X=1000780 $Y=92155
X37704 VSS: 2 VSS: 5282 4500 2 BUFX8_HS $T=1014300 96600 1 0 $X=1014120 $Y=92155
X37708 VSS: 2 VSS: 5177 5212 2 BUFX4_HS $T=1000960 96600 0 0 $X=1000780 $Y=96335
X37709 VSS: 2 VSS: 3181 5212 2 BUFX16_HS $T=1004640 96600 0 0 $X=1004460 $Y=96335
X37716 VSS: 2 VSS: 2839 5284 2 BUFX16_HS $T=1023500 104880 0 180 $X=1013200 $Y=100435
X37723 VSS: 2 VSS: 5252 4736 2 BUFX2 $T=1006020 104880 0 0 $X=1005840 $Y=104615
X37726 VSS: 2 VSS: 5285 4206 2 BUFX16_HS $T=1015680 104880 0 0 $X=1015500 $Y=104615
X37735 VSS: 2 VSS: 3247 5254 2 BUFX16_HS $T=1001880 113160 0 0 $X=1001700 $Y=112895
X37736 VSS: 2 VSS: 5287 5254 2 BUFX16_HS $T=1012000 113160 0 0 $X=1011820 $Y=112895
X37741 VSS: 2 VSS: 5249 5217 2 CLKINVX2_HS $T=1016140 121440 0 180 $X=1012280 $Y=116995
X37746 VSS: 2 VSS: 5254 5218 2 BUFX2_HS $T=1004180 121440 0 0 $X=1004000 $Y=121175
X37748 VSS: 2 VSS: 3500 5216 2 BUFX16_HS $T=1008780 121440 0 0 $X=1008600 $Y=121175
X37752 VSS: 2 VSS: 5255 5215 2 INVX8_HS $T=1013840 129720 1 0 $X=1013660 $Y=125275
X37761 VSS: 2 VSS: 5256 5218 2 CLKBUFX4 $T=1007860 129720 0 0 $X=1007680 $Y=129455
X37765 VSS: 2 VSS: 4840 5219 2 BUFX16_HS $T=1003260 138000 1 0 $X=1003080 $Y=133555
X37772 VSS: 2 VSS: 2620 5291 2 BUFX16_HS $T=1020280 138000 1 180 $X=1009980 $Y=137735
X37775 VSS: 2 VSS: 5025 4781 2 BUFX16_HS $T=1019820 146280 0 180 $X=1009520 $Y=141835
X37779 VSS: 2 VSS: 5257 4745 2 BUFX2 $T=1000500 146280 0 0 $X=1000320 $Y=146015
X37780 VSS: 2 VSS: 2 2 TIEHI $T=1002800 146280 0 0 $X=1002620 $Y=146015
X37784 VSS: 2 VSS: 5129 4145 2 CLKBUFX8 $T=1012460 146280 0 0 $X=1012280 $Y=146015
X37859 VSS: 2 VSS: 5222 5260 2 CLKBUFX4 $T=1004180 510600 0 180 $X=1001240 $Y=506155
X37862 VSS: 2 VSS: 5259 4261 2 CLKBUFX2 $T=1005560 510600 1 0 $X=1005380 $Y=506155
X37865 VSS: 2 VSS: 5294 4569 2 BUFX8_HS $T=1012460 510600 1 0 $X=1012280 $Y=506155
X37873 VSS: 2 VSS: 5109 7950 1926 5092 2 DFFX1_HS $T=1011540 510600 0 0 $X=1011360 $Y=510335
X37876 VSS: 2 VSS: 5262 5261 3317 2 NAND2X1 $T=1006940 518880 0 180 $X=1004920 $Y=514435
X37884 VSS: 2 VSS: 5263 5228 5262 2568 2 AOI21X1 $T=1004640 518880 0 0 $X=1004460 $Y=518615
X37889 VSS: 2 VSS: 5295 7951 1926 4967 2 DFFX1_HS $T=1015680 518880 0 0 $X=1015500 $Y=518615
X37891 VSS: 2 VSS: 5228 7952 1926 5096 2 DFFX1_HS $T=1004180 527160 1 0 $X=1004000 $Y=522715
X37899 VSS: 2 VSS: 4451 7953 1926 5098 2 DFFX1_HS $T=1006940 527160 0 0 $X=1006760 $Y=526895
X37911 VSS: 2 VSS: rdata_o[14] 5265 5111 5264 5263 2 NAND4X1 $T=1012000 535440 1 180 $X=1009060 $Y=535175
X37918 VSS: 2 VSS: 5061 7954 1926 4884 2 DFFX1_HS $T=1008780 543720 1 0 $X=1008600 $Y=539275
X37930 VSS: 2 VSS: 5298 7955 1926 5224 2 DFFX1_HS $T=1013840 552000 1 0 $X=1013660 $Y=547555
X37938 VSS: 2 VSS: 5267 7956 1926 5102 2 DFFX1_HS $T=1006940 552000 0 0 $X=1006760 $Y=551735
X37951 VSS: 2 VSS: 5268 7957 1926 5105 2 DFFX1_HS $T=1012460 560280 0 0 $X=1012280 $Y=560015
X37967 VSS: 2 VSS: 5227 7958 1926 5056 2 DFFX1_HS $T=1001880 576840 1 0 $X=1001700 $Y=572395
X37985 VSS: 2 VSS: 5115 5267 2006 2007 5227 2 AOI22X1 $T=1001420 585120 0 0 $X=1001240 $Y=584855
X38000 VSS: 2 VSS: 5271 5104 5109 5268 5103 2 AOI22X2_HS $T=1015220 593400 1 180 $X=1009520 $Y=593135
X38012 VSS: 2 VSS: 5060 5268 1695 1716 5231 2 AOI22X1 $T=1008320 601680 0 0 $X=1008140 $Y=601415
X38043 VSS: 2 VSS: 5272 4349 2555 2564 5116 2 AOI22X1 $T=1005100 626520 1 0 $X=1004920 $Y=622075
X38058 VSS: 2 VSS: 2629 5307 2 BUFX16_HS $T=1021200 634800 0 180 $X=1010900 $Y=630355
X38092 VSS: 2 VSS: 5313 5210 2 BUFX4_HS $T=1030860 22080 1 0 $X=1030680 $Y=17635
X38096 VSS: 2 VSS: 5242 5210 2 BUFX2 $T=1025800 22080 1 180 $X=1023320 $Y=21815
X38113 VSS: 2 VSS: 5240 5273 5035 5163 5274 2 AOI22X2_HS $T=1018900 38640 1 0 $X=1018720 $Y=34195
X38128 VSS: 2 VSS: 5275 4312 2 BUFX8_HS $T=1025800 46920 1 0 $X=1025620 $Y=42475
X38134 VSS: 2 VSS: 5163 7959 2627 5322 2 DFFX1_HS $T=1031780 46920 0 0 $X=1031600 $Y=46655
X38139 VSS: 2 VSS: 5276 3466 5205 5127 5243 2 AOI22X1_HS $T=1020280 55200 0 180 $X=1016880 $Y=50755
X38144 VSS: 2 VSS: 5245 5277 5276 2 CLKAND2X2 $T=1018900 55200 1 180 $X=1016420 $Y=54935
X38153 VSS: 2 VSS: 5277 5203 5124 5273 5246 2 AOI22X1_HS $T=1016140 63480 1 0 $X=1015960 $Y=59035
X38162 VSS: 2 VSS: 4497 7960 2627 5278 2 DFFX1_HS $T=1025340 63480 0 0 $X=1025160 $Y=63215
X38169 VSS: 2 VSS: 5278 4457 2 CLKBUFX4 $T=1032240 71760 0 180 $X=1029300 $Y=67315
X38175 VSS: 2 VSS: 5201 7961 2627 5279 2 DFFX1_HS $T=1026720 71760 0 0 $X=1026540 $Y=71495
X38182 VSS: 2 VSS: 5204 7962 2677 5279 2 DFFX1_HS $T=1024880 80040 1 0 $X=1024700 $Y=75595
X38184 VSS: 2 VSS: 5280 5249 2 CLKINVX4 $T=1017060 80040 0 0 $X=1016880 $Y=79775
X38194 VSS: 2 VSS: 5246 3181 2 CLKBUFX2 $T=1024880 88320 0 180 $X=1022400 $Y=83875
X38199 VSS: 2 VSS: 5281 4650 2 BUFX2 $T=1016600 88320 0 0 $X=1016420 $Y=88055
X38213 VSS: 2 VSS: 5274 5177 2 BUFX16_HS $T=1017060 96600 0 0 $X=1016880 $Y=96335
X38214 VSS: 2 VSS: 5168 7963 2677 5283 2 DFFX1_HS $T=1027180 96600 0 0 $X=1027000 $Y=96335
X38222 VSS: 2 VSS: 5161 7964 2627 5283 2 DFFX1_HS $T=1030400 104880 1 0 $X=1030220 $Y=100435
X38230 VSS: 2 VSS: 3676 5286 2 CLKBUFX8 $T=1026260 113160 0 180 $X=1021020 $Y=108715
X38233 VSS: 2 VSS: 5288 5011 2 BUFX16_HS $T=1022120 113160 0 0 $X=1021940 $Y=112895
X38241 VSS: 2 VSS: 5289 4734 2 BUFX2 $T=1023960 121440 1 0 $X=1023780 $Y=116995
X38247 VSS: 2 VSS: 5273 4082 2 BUFX8 $T=1029020 121440 1 180 $X=1023780 $Y=121175
X38257 VSS: 2 VSS: 3801 5255 2 BUFX16_HS $T=1018440 129720 0 0 $X=1018260 $Y=129455
X38265 VSS: 2 VSS: 5290 5141 2 BUFX4_HS $T=1022580 138000 1 0 $X=1022400 $Y=133555
X38269 VSS: 2 VSS: 2624 5292 2 BUFX16_HS $T=1030400 138000 1 180 $X=1020100 $Y=137735
X38276 VSS: 2 VSS: 5333 5217 2 BUFX16_HS $T=1025340 146280 1 0 $X=1025160 $Y=141835
X38359 VSS: 2 VSS: 4401 5293 2 CLKBUFX8 $T=1028560 502320 0 0 $X=1028380 $Y=502055
X38377 VSS: 2 VSS: 5261 5296 2312 2311 5295 2 AOI22X1 $T=1023040 518880 1 0 $X=1022860 $Y=514435
X38381 VSS: 2 VSS: 5296 7965 1926 4968 2 DFFX1_HS $T=1026720 518880 0 0 $X=1026540 $Y=518615
X38394 VSS: 2 VSS: 5297 7966 1926 5053 2 DFFX1_HS $T=1030860 527160 0 0 $X=1030680 $Y=526895
X38401 VSS: 2 VSS: 5264 4451 2991 2992 5297 2 AOI22X1 $T=1026720 535440 0 180 $X=1023780 $Y=530995
X38416 VSS: 2 VSS: 5265 4410 2785 2796 5298 2 AOI22X1 $T=1020280 543720 1 180 $X=1017340 $Y=543455
X38439 VSS: 2 VSS: 5231 7967 1926 5023 2 DFFX1_HS $T=1023960 560280 1 0 $X=1023780 $Y=555835
X38451 VSS: 2 VSS: 5269 4840 5296 5061 4729 2 AOI22X1_HS $T=1023500 568560 1 180 $X=1020100 $Y=568295
X38463 VSS: 2 VSS: 5345 5144 5298 5267 5190 2 AOI22X1_HS $T=1035460 576840 0 180 $X=1032060 $Y=572395
X38466 VSS: 2 VSS: 5300 4127 5061 5296 3491 2 AOI22X2_HS $T=1023960 576840 1 180 $X=1018260 $Y=576575
X38475 VSS: 2 VSS: 5270 3540 4705 5109 5268 2 AOI22X1_HS $T=1022120 585120 0 180 $X=1018720 $Y=580675
X38480 VSS: 2 VSS: 5301 5300 5270 2 AND2X1_HS $T=1019820 585120 0 0 $X=1019640 $Y=584855
X38489 VSS: 2 VSS: 5303 5269 5271 2 NAND2X2_HS $T=1020280 593400 1 0 $X=1020100 $Y=588955
X38503 VSS: 2 VSS: 5304 5303 2 INVX2_HS $T=1025800 601680 1 0 $X=1025620 $Y=597235
X38515 VSS: 2 VSS: 4630 5304 5302 2 NAND2X4_HS $T=1025340 609960 0 180 $X=1020100 $Y=605515
X38518 VSS: 2 VSS: 4940 5299 5301 2 NAND2X4_HS $T=1023960 609960 1 180 $X=1018720 $Y=609695
X38529 VSS: 2 VSS: 5354 4914 5348 5352 3801 2 AOI22X2 $T=1036840 618240 0 180 $X=1032060 $Y=613795
X38543 VSS: 2 VSS: 5307 5305 5306 2 NAND2X2_HS $T=1025800 626520 1 180 $X=1022400 $Y=626255
X38555 VSS: 2 VSS: 5305 5308 4553 2 NOR2X4_HS $T=1026720 634800 1 180 $X=1021480 $Y=634535
X38572 VSS: 2 VSS: 5311 3505 5310 5309 3500 2 AOI22X2_HS $T=1049720 13800 0 180 $X=1044020 $Y=9355
X38580 VSS: 2 VSS: 5312 5309 5310 3501 3508 2 AOI22X2_HS $T=1042360 13800 0 0 $X=1042180 $Y=13535
X38594 VSS: 2 VSS: 5314 3500 5316 5315 3505 2 AOI22X1_HS $T=1050180 22080 1 180 $X=1046780 $Y=21815
X38600 VSS: 2 VSS: 5317 3501 5315 5316 3508 2 AOI22X2 $T=1043280 30360 1 0 $X=1043100 $Y=25915
X38609 VSS: 2 VSS: 4864 4755 2 CLKBUFX8 $T=1047420 30360 0 0 $X=1047240 $Y=30095
X38620 VSS: 2 VSS: 5319 5310 3183 2808 5318 2 AOI22X1 $T=1043740 38640 0 0 $X=1043560 $Y=38375
X38627 VSS: 2 VSS: 5321 5315 3183 2808 5320 2 AOI22X1 $T=1048340 46920 0 180 $X=1045400 $Y=42475
X38638 VSS: 2 VSS: 5320 7195 4461 5322 2 DFFX4_HS $T=1040520 55200 1 0 $X=1040340 $Y=50755
X38647 VSS: 2 VSS: 5203 7968 2677 5322 2 DFFX1_HS $T=1033160 63480 1 0 $X=1032980 $Y=59035
X38658 VSS: 2 VSS: 5072 7969 2627 5367 2 DFFX1_HS $T=1048340 63480 0 0 $X=1048160 $Y=63215
X38660 VSS: 2 VSS: 5318 7970 4463 5322 2 DFFX1_HS $T=1034540 71760 1 0 $X=1034360 $Y=67315
X38670 VSS: 2 VSS: 5127 7971 2677 5367 2 DFFX1_HS $T=1047880 71760 0 0 $X=1047700 $Y=71495
X38673 VSS: 2 VSS: 5310 7972 4463 5279 2 DFFX1_HS $T=1039600 80040 1 0 $X=1039420 $Y=75595
X38679 VSS: 2 VSS: 5323 7973 4396 5279 2 DFFX1_HS $T=1036380 80040 0 0 $X=1036200 $Y=79775
X38683 VSS: 2 VSS: 5315 7196 4461 5279 2 DFFX4_HS $T=1037300 88320 1 0 $X=1037120 $Y=83875
X38691 VSS: 2 VSS: 5324 3505 5323 5325 3500 2 AOI22X2 $T=1041900 88320 0 0 $X=1041720 $Y=88055
X38694 VSS: 2 VSS: 5326 3501 5323 5325 3508 2 AOI22X2_HS $T=1043740 96600 0 180 $X=1038040 $Y=92155
X38701 VSS: 2 VSS: 5316 7197 4461 5283 2 DFFX4_HS $T=1040060 96600 0 0 $X=1039880 $Y=96335
X38708 VSS: 2 VSS: 5325 7198 4396 5283 2 DFFX4_HS $T=1033160 104880 0 0 $X=1032980 $Y=104615
X38720 VSS: 2 VSS: 5309 7974 4463 5283 2 DFFX1_HS $T=1036840 113160 0 0 $X=1036660 $Y=112895
X38722 VSS: 2 VSS: 5327 7199 4530 5283 2 DFFX4_HS $T=1033620 121440 1 0 $X=1033440 $Y=116995
X38730 VSS: 2 VSS: 5328 7200 4530 5279 2 DFFX4_HS $T=1035920 121440 0 0 $X=1035740 $Y=121175
X38734 VSS: 2 VSS: 5329 3501 5328 5327 3508 2 AOI22X2_HS $T=1041440 129720 0 180 $X=1035740 $Y=125275
X38743 VSS: 2 VSS: 5330 3500 5327 5328 3505 2 AOI22X1_HS $T=1040520 129720 0 0 $X=1040340 $Y=129455
X38748 VSS: 2 VSS: 5331 5290 2 BUFX16_HS $T=1038220 138000 1 0 $X=1038040 $Y=133555
X38754 VSS: 2 VSS: 5104 5141 2 BUFX16_HS $T=1034540 138000 0 0 $X=1034360 $Y=137735
X38759 VSS: 2 VSS: 5332 7975 4331 5279 2 DFFX1_HS $T=1040060 146280 1 0 $X=1039880 $Y=141835
X38766 VSS: 2 VSS: 5335 3501 5332 5334 3508 2 AOI22X2_HS $T=1047880 146280 1 180 $X=1042180 $Y=146015
X38845 VSS: 2 VSS: 5337 3313 2 BUFX4 $T=1042360 510600 1 0 $X=1042180 $Y=506155
X38858 VSS: 2 VSS: 5339 3540 5338 5336 4705 2 AOI22X1_HS $T=1043280 518880 1 0 $X=1043100 $Y=514435
X38868 VSS: 2 VSS: 5340 7201 2945 5096 2 DFFX4_HS $T=1039140 527160 1 0 $X=1038960 $Y=522715
X38884 VSS: 2 VSS: 5338 7976 4466 5105 2 DFFX1_HS $T=1037760 535440 0 0 $X=1037580 $Y=535175
X38888 VSS: 2 VSS: 5341 5016 5297 5295 3620 2 AOI22X2_HS $T=1040060 543720 1 0 $X=1039880 $Y=539275
X38895 VSS: 2 VSS: 4378 7202 2945 4469 2 DFFX4_HS $T=1037300 543720 0 0 $X=1037120 $Y=543455
X38896 VSS: 2 VSS: 5342 7203 2945 5224 2 DFFX4_HS $T=1032700 552000 1 0 $X=1032520 $Y=547555
X38905 VSS: 2 VSS: 5343 2997 5295 5297 4657 2 AOI22X1_HS $T=1039600 552000 0 0 $X=1039420 $Y=551735
X38919 VSS: 2 VSS: 5344 3541 5267 5298 3313 2 AOI22X1 $T=1041900 560280 1 180 $X=1038960 $Y=560015
X38925 VSS: 2 VSS: 5299 5344 5343 2 AND2X1_HS $T=1039600 568560 0 180 $X=1036660 $Y=564115
X38937 VSS: 2 VSS: 5471 7204 3904 5105 2 DFFX4_HS $T=1047420 568560 0 0 $X=1047240 $Y=568295
X38958 VSS: 2 VSS: 5302 5341 5345 2 AND2X1_HS $T=1037300 585120 0 0 $X=1037120 $Y=584855
X38966 VSS: 2 VSS: 5346 3534 5340 5347 4733 2 AOI22X2_HS $T=1052940 593400 0 180 $X=1047240 $Y=588955
X38972 VSS: 2 VSS: 5349 4347 2317 2343 5348 2 AOI22X1 $T=1040980 593400 0 0 $X=1040800 $Y=593135
X38979 VSS: 2 VSS: 5474 7205 2945 4893 2 DFFX4_HS $T=1047420 601680 1 0 $X=1047240 $Y=597235
X38986 VSS: 2 VSS: 5350 4374 5347 5340 4969 2 AOI22X2_HS $T=1041440 601680 0 0 $X=1041260 $Y=601415
X39013 VSS: 2 VSS: 5355 4617 5348 5352 4971 2 AOI22X2_HS $T=1046040 618240 1 180 $X=1040340 $Y=617975
X39017 VSS: 2 VSS: 5238 5356 5350 5355 5353 2 NAND4X4_HS $T=1039140 626520 1 0 $X=1038960 $Y=622075
X39027 VSS: 2 VSS: 5356 3859 5116 5357 4216 2 AOI22X1_HS $T=1048340 626520 0 0 $X=1048160 $Y=626255
X39031 VSS: 2 VSS: 5358 5025 5357 5116 5026 2 AOI22X2_HS $T=1040980 634800 1 0 $X=1040800 $Y=630355
X39039 VSS: 2 VSS: 5359 5358 5346 2 AND2X1_HS $T=1046040 634800 1 180 $X=1043100 $Y=634535
X39041 VSS: 2 VSS: 5119 5354 5351 5359 2 NAND3X4_HS $T=1033160 643080 1 0 $X=1032980 $Y=638635
X39081 VSS: 2 VSS: 5360 3828 5320 5361 4336 2 AOI22X2_HS $T=1062600 30360 1 180 $X=1056900 $Y=30095
X39090 VSS: 2 VSS: 5362 5273 5361 5320 5274 2 AOI22X2_HS $T=1057080 38640 1 0 $X=1056900 $Y=34195
X39103 VSS: 2 VSS: 5482 5364 5363 2 AND2X1_HS $T=1063060 46920 1 0 $X=1062880 $Y=42475
X39107 VSS: 2 VSS: 5364 4336 5365 5318 3828 2 AOI22X1_HS $T=1061220 46920 0 0 $X=1061040 $Y=46655
X39117 VSS: 2 VSS: 5205 7977 2677 5366 2 DFFX1_HS $T=1051100 55200 0 0 $X=1050920 $Y=54935
X39126 VSS: 2 VSS: 5166 7978 2627 5366 2 DFFX1_HS $T=1051100 63480 1 0 $X=1050920 $Y=59035
X39139 VSS: 2 VSS: 4560 7979 2627 5368 2 DFFX1_HS $T=1060760 71760 1 0 $X=1060580 $Y=67315
X39143 VSS: 2 VSS: 4819 4882 2 CLKBUFX4 $T=1060300 71760 0 0 $X=1060120 $Y=71495
X39144 VSS: 2 VSS: 4773 7980 2677 5368 2 DFFX1_HS $T=1063060 71760 0 0 $X=1062880 $Y=71495
X39155 VSS: 2 VSS: 5369 7206 4396 5322 2 DFFX4_HS $T=1053400 80040 0 0 $X=1053220 $Y=79775
X39186 VSS: 2 VSS: 5124 7981 2677 5370 2 DFFX1_HS $T=1051560 104880 1 0 $X=1051380 $Y=100435
X39191 VSS: 2 VSS: 5365 7982 4463 5370 2 DFFX1_HS $T=1054320 104880 0 0 $X=1054140 $Y=104615
X39198 VSS: 2 VSS: 5035 7983 2627 5370 2 DFFX1_HS $T=1051560 113160 1 0 $X=1051380 $Y=108715
X39207 VSS: 2 VSS: 5490 7984 4396 5370 2 DFFX1_HS $T=1063980 113160 0 0 $X=1063800 $Y=112895
X39213 VSS: 2 VSS: 5371 7207 4530 5322 2 DFFX4_HS $T=1050180 121440 1 0 $X=1050000 $Y=116995
X39219 VSS: 2 VSS: 5372 5328 3183 2808 5371 2 AOI22X1 $T=1058000 121440 0 0 $X=1057820 $Y=121175
X39231 VSS: 2 VSS: 5496 5273 5494 5371 3356 2 AOI22X2_HS $T=1063060 129720 1 0 $X=1062880 $Y=125275
X39244 VSS: 2 VSS: 5500 4501 2 BUFX16_HS $T=1061220 138000 1 0 $X=1061040 $Y=133555
X39248 VSS: 2 VSS: 5373 4501 2 BUFX16_HS $T=1066280 138000 1 180 $X=1055980 $Y=137735
X39253 VSS: 2 VSS: 5334 7985 4331 5283 2 DFFX1_HS $T=1050180 146280 1 0 $X=1050000 $Y=141835
X39266 VSS: 2 VSS: 5374 4656 2 BUFX2 $T=1059380 154560 1 0 $X=1059200 $Y=150115
X39270 VSS: 2 VSS: 5375 3500 5334 5332 3505 2 AOI22X1_HS $T=1064440 154560 1 180 $X=1061040 $Y=154295
X39278 VSS: 2 VSS: 5376 5332 3183 2808 5377 2 AOI22X1 $T=1058920 162840 1 0 $X=1058740 $Y=158395
X39282 VSS: 2 VSS: 5377 7986 4331 5322 2 DFFX1_HS $T=1056620 162840 0 0 $X=1056440 $Y=162575
X39287 VSS: 2 VSS: 4987 4426 2 BUFX16_HS $T=1064900 171120 0 180 $X=1054600 $Y=166675
X39299 VSS: 2 VSS: 5380 3505 5378 5379 3500 2 AOI22X2 $T=1059840 179400 1 0 $X=1059660 $Y=174955
X39313 VSS: 2 VSS: 5515 5274 5273 5381 5517 2 AOI22X2 $T=1062600 187680 1 0 $X=1062420 $Y=183235
X39315 VSS: 2 VSS: 5379 7987 4964 5283 2 DFFX1_HS $T=1054780 187680 0 0 $X=1054600 $Y=187415
X39322 VSS: 2 VSS: 5378 7988 4964 5279 2 DFFX1_HS $T=1059380 195960 1 0 $X=1059200 $Y=191515
X39331 VSS: 2 VSS: 5382 2596 2 BUFX2_HS $T=1055700 204240 1 0 $X=1055520 $Y=199795
X39333 VSS: 2 VSS: 5092 5129 2 CLKBUFX8 $T=1065360 204240 0 180 $X=1060120 $Y=199795
X39334 VSS: 2 VSS: 5026 3867 2 BUFX16_HS $T=1063980 204240 1 180 $X=1053680 $Y=203975
X39342 VSS: 2 VSS: 5383 3828 2 BUFX8_HS $T=1067200 212520 0 180 $X=1061500 $Y=208075
X39343 VSS: 2 VSS: 4681 4082 2 BUFX16_HS $T=1053860 212520 0 0 $X=1053680 $Y=212255
X39349 VSS: 2 VSS: 4507 5384 2 CLKBUFX8 $T=1058920 220800 0 180 $X=1053680 $Y=216355
X39352 VSS: 2 VSS: 5386 7989 4964 5385 2 DFFX1_HS $T=1053860 220800 0 0 $X=1053680 $Y=220535
X39353 VSS: 2 VSS: 5528 7990 4964 5092 2 DFFX1_HS $T=1063060 220800 0 0 $X=1062880 $Y=220535
X39362 VSS: 2 VSS: 5529 5331 5528 5387 5103 2 AOI22X1 $T=1067200 229080 0 180 $X=1064260 $Y=224635
X39363 VSS: 2 VSS: 4457 4928 2 CLKBUFX8 $T=1053860 229080 0 0 $X=1053680 $Y=228815
X39364 VSS: 2 VSS: 5389 5386 2312 2311 5388 2 AOI22X1 $T=1061680 229080 1 180 $X=1058740 $Y=228815
X39370 VSS: 2 VSS: 5388 7991 4964 5018 2 DFFX1_HS $T=1054320 237360 1 0 $X=1054140 $Y=232915
X39373 VSS: 2 VSS: 5390 5216 2 BUFX16_HS $T=1054780 237360 0 0 $X=1054600 $Y=237095
X39382 VSS: 2 VSS: 5387 7992 4964 5105 2 DFFX1_HS $T=1053860 245640 0 0 $X=1053680 $Y=245375
X39389 VSS: 2 VSS: 5391 5389 3285 2 NAND2X1 $T=1058000 253920 0 180 $X=1055980 $Y=249475
X39394 VSS: 2 VSS: 5105 5137 2 CLKBUFX8 $T=1055240 253920 0 0 $X=1055060 $Y=253655
X39404 VSS: 2 VSS: 5392 7993 4964 5393 2 DFFX1_HS $T=1057080 262200 1 0 $X=1056900 $Y=257755
X39405 VSS: 2 VSS: 794 5394 2 BUFX16_HS $T=1063980 262200 1 180 $X=1053680 $Y=261935
X39410 VSS: 2 VSS: 5396 5214 2 CLKBUFX4 $T=1056620 270480 0 180 $X=1053680 $Y=266035
X39411 VSS: 2 VSS: 302 5395 2 BUFX16_HS $T=1056620 270480 1 0 $X=1056440 $Y=266035
X39415 VSS: 2 VSS: 4651 5148 2 CLKBUFX8 $T=1062140 270480 0 0 $X=1061960 $Y=270215
X39423 VSS: 2 VSS: 5395 5398 5397 2 NAND2X2_HS $T=1063980 278760 0 180 $X=1060580 $Y=274315
X39424 VSS: 2 VSS: 5398 5399 5554 2 NOR2X2_HS $T=1063980 278760 1 0 $X=1063800 $Y=274315
X39425 VSS: 2 VSS: 5214 5149 2 CLKBUFX4 $T=1053860 278760 0 0 $X=1053680 $Y=278495
X39427 VSS: 2 VSS: 5402 5400 2312 2311 5401 2 AOI22X1 $T=1059840 278760 1 180 $X=1056900 $Y=278495
X39437 VSS: 2 VSS: 5056 4732 2 CLKBUFX8 $T=1053860 287040 0 0 $X=1053680 $Y=286775
X39438 VSS: 2 VSS: 5403 5402 3945 2 NAND2X1 $T=1060760 287040 1 180 $X=1058740 $Y=286775
X39441 VSS: 2 VSS: 5555 5558 5413 5557 5559 2 NAND4X2_HS $T=1070420 287040 1 180 $X=1064720 $Y=286775
X39446 VSS: 2 VSS: 5404 7994 4964 5056 2 DFFX1_HS $T=1054320 295320 1 0 $X=1054140 $Y=290875
X39449 VSS: 2 VSS: 5406 5405 5403 2568 2 AOI21X1 $T=1059840 295320 1 180 $X=1057360 $Y=295055
X39458 VSS: 2 VSS: 5562 7995 1824 5393 2 DFFX1_HS $T=1058460 303600 1 0 $X=1058280 $Y=299155
X39459 VSS: 2 VSS: 4145 5407 2 CLKBUFX8 $T=1058920 303600 1 180 $X=1053680 $Y=303335
X39468 VSS: 2 VSS: 5408 3534 2 BUFX8_HS $T=1067200 311880 0 180 $X=1061500 $Y=307435
X39473 VSS: 2 VSS: 5399 5569 5409 5410 2 NAND3X2_HS $T=1063520 311880 0 0 $X=1063340 $Y=311615
X39480 VSS: 2 VSS: 5410 5408 5405 5411 3496 2 AOI22X1_HS $T=1066280 320160 0 180 $X=1062880 $Y=315715
X39484 VSS: 2 VSS: 4732 5150 2 CLKBUFX8 $T=1062140 320160 0 0 $X=1061960 $Y=319895
X39488 VSS: 2 VSS: 5411 7996 1824 5056 2 DFFX1_HS $T=1053860 328440 1 0 $X=1053680 $Y=323995
X39489 VSS: 2 VSS: 5414 7997 1824 5092 2 DFFX1_HS $T=1063060 328440 1 0 $X=1062880 $Y=323995
X39491 VSS: 2 VSS: 384 5412 2 BUFX16_HS $T=1064440 328440 1 180 $X=1054140 $Y=328175
X39498 VSS: 2 VSS: 135 2 TIEHI $T=1055240 336720 1 0 $X=1055060 $Y=332275
X39502 VSS: 2 VSS: 5413 5414 5415 5103 5104 2 AOI22X1_HS $T=1061680 336720 1 0 $X=1061500 $Y=332275
X39505 VSS: 2 VSS: 5137 4970 2 CLKBUFX8 $T=1053860 336720 0 0 $X=1053680 $Y=336455
X39509 VSS: 2 VSS: 5415 8168 1824 135 5105 2 DFFRX1_HS $T=1062140 336720 0 0 $X=1061960 $Y=336455
X39513 VSS: 2 VSS: 5405 7998 1824 5096 2 DFFX1_HS $T=1053860 345000 1 0 $X=1053680 $Y=340555
X39518 VSS: 2 VSS: 5543 7999 4964 5096 2 DFFX1_HS $T=1062140 345000 0 0 $X=1061960 $Y=344735
X39522 VSS: 2 VSS: 4928 5417 2 CLKBUFX8 $T=1058920 353280 0 180 $X=1053680 $Y=348835
X39523 VSS: 2 VSS: 5416 3305 3149 2 NOR2X2 $T=1058920 353280 1 0 $X=1058740 $Y=348835
X39526 VSS: 2 VSS: 4669 5216 2 BUFX8_HS $T=1054320 353280 0 0 $X=1054140 $Y=353015
X39528 VSS: 2 VSS: 5561 8000 1824 5224 2 DFFX1_HS $T=1061680 353280 0 0 $X=1061500 $Y=353015
X39534 VSS: 2 VSS: 4970 5418 2 CLKBUFX8 $T=1063060 361560 0 180 $X=1057820 $Y=357115
X39536 VSS: 2 VSS: 5419 8001 4964 5224 2 DFFX1_HS $T=1053860 361560 0 0 $X=1053680 $Y=361295
X39544 VSS: 2 VSS: 5149 5420 2 CLKBUFX8 $T=1061680 369840 0 180 $X=1056440 $Y=365395
X39548 VSS: 2 VSS: 5424 5423 5422 5421 2 OAI21X1_HS $T=1059380 369840 0 0 $X=1059200 $Y=369575
X39555 VSS: 2 VSS: 5393 5425 2 CLKBUFX8 $T=1063520 378120 0 180 $X=1058280 $Y=373675
X39559 VSS: 2 VSS: 5426 2 TIELO $T=1055700 378120 0 0 $X=1055520 $Y=377855
X39563 VSS: 2 VSS: 5427 2 TIELO $T=1063520 378120 0 0 $X=1063340 $Y=377855
X39570 VSS: 2 VSS: 5429 5426 5430 5428 2 ICGPRECX1 $T=1065360 386400 0 180 $X=1056440 $Y=381955
X39571 VSS: 2 VSS: 2544 5216 2 BUFX16_HS $T=1053860 386400 0 0 $X=1053680 $Y=386135
X39577 VSS: 2 VSS: 4509 5431 2 CLKBUFX8 $T=1059840 394680 0 180 $X=1054600 $Y=390235
X39579 VSS: 2 VSS: 5150 5590 2 CLKBUFX8 $T=1066740 394680 0 180 $X=1061500 $Y=390235
X39580 VSS: 2 VSS: 5432 2 TIELO $T=1055240 394680 1 180 $X=1053680 $Y=394415
X39588 VSS: 2 VSS: 4755 5433 2 CLKBUFX8 $T=1059380 402960 0 180 $X=1054140 $Y=398515
X39589 VSS: 2 VSS: 5434 2 TIELO $T=1059380 402960 1 0 $X=1059200 $Y=398515
X39591 VSS: 2 VSS: 5286 4509 2 CLKBUFX8 $T=1066280 402960 0 180 $X=1061040 $Y=398515
X39601 VSS: 2 VSS: 5437 5416 424 5436 2 AOI21X1 $T=1058000 411240 1 0 $X=1057820 $Y=406795
X39602 VSS: 2 VSS: 4882 5435 2 CLKBUFX8 $T=1065360 411240 0 180 $X=1060120 $Y=406795
X39612 VSS: 2 VSS: 5436 5438 2 CLKINVX1 $T=1056160 419520 1 0 $X=1055980 $Y=415075
X39615 VSS: 2 VSS: 5438 5439 2 CLKINVX2 $T=1061680 419520 1 0 $X=1061500 $Y=415075
X39621 VSS: 2 VSS: 5148 5440 2 CLKBUFX4 $T=1060300 419520 0 0 $X=1060120 $Y=419255
X39628 VSS: 2 VSS: 4881 5437 2287 2 CLKAND2X2 $T=1060760 427800 0 180 $X=1058280 $Y=423355
X39632 VSS: 2 VSS: 5293 5429 2 CLKBUFX2 $T=1057540 427800 0 0 $X=1057360 $Y=427535
X39633 VSS: 2 VSS: 5439 5441 3320 2 NOR2X1_HS $T=1059840 427800 0 0 $X=1059660 $Y=427535
X39641 VSS: 2 VSS: 5442 3319 5444 2 NAND2X2 $T=1057080 436080 1 0 $X=1056900 $Y=431635
X39645 VSS: 2 VSS: 5443 3321 5445 2 NAND2X2 $T=1062600 436080 1 0 $X=1062420 $Y=431635
X39646 VSS: 2 VSS: 4859 5604 2 CLKBUFX8 $T=1069960 436080 0 180 $X=1064720 $Y=431635
X39648 VSS: 2 VSS: 5446 5447 2 CLKBUFX8 $T=1057540 436080 0 0 $X=1057360 $Y=435815
X39654 VSS: 2 VSS: 5448 2 TIELO $T=1057540 444360 1 0 $X=1057360 $Y=439915
X39657 VSS: 2 VSS: 4664 5605 2 CLKBUFX8 $T=1069500 444360 0 180 $X=1064260 $Y=439915
X39659 VSS: 2 VSS: 5444 3321 3320 2 NOR2X1 $T=1059380 444360 1 180 $X=1057360 $Y=444095
X39660 VSS: 2 VSS: 5401 8002 1824 4967 2 DFFX1_HS $T=1059380 444360 0 0 $X=1059200 $Y=444095
X39664 VSS: 2 VSS: 4105 5449 2 CLKBUFX8 $T=1058920 452640 0 180 $X=1053680 $Y=448195
X39668 VSS: 2 VSS: 4032 5255 2 BUFX16_HS $T=1064440 452640 1 180 $X=1054140 $Y=452375
X39674 VSS: 2 VSS: 4925 5450 2 CLKBUFX4 $T=1056620 460920 0 180 $X=1053680 $Y=456475
X39676 VSS: 2 VSS: 5453 3496 5452 5451 5408 2 AOI22X1_HS $T=1058460 460920 1 0 $X=1058280 $Y=456475
X39677 VSS: 2 VSS: 4702 5614 2 CLKBUFX8 $T=1066740 460920 0 180 $X=1061500 $Y=456475
X39678 VSS: 2 VSS: 5452 8003 4466 5056 2 DFFX1_HS $T=1053860 460920 0 0 $X=1053680 $Y=460655
X39679 VSS: 2 VSS: 5451 8004 4466 5096 2 DFFX1_HS $T=1063060 460920 0 0 $X=1062880 $Y=460655
X39683 VSS: 2 VSS: 5224 5454 2 CLKBUFX4 $T=1056620 469200 0 180 $X=1053680 $Y=464755
X39686 VSS: 2 VSS: 5447 4876 2 CLKBUFX8 $T=1065820 469200 0 180 $X=1060580 $Y=464755
X39688 VSS: 2 VSS: 5455 5456 3899 2 NAND2X1 $T=1057540 469200 0 0 $X=1057360 $Y=468935
X39696 VSS: 2 VSS: 4876 4702 2 CLKBUFX8 $T=1064440 477480 0 180 $X=1059200 $Y=473035
X39700 VSS: 2 VSS: 5537 4657 2 BUFX8 $T=1061220 477480 0 0 $X=1061040 $Y=477215
X39704 VSS: 2 VSS: 4469 4876 2 CLKBUFX8 $T=1058920 485760 0 180 $X=1053680 $Y=481315
X39705 VSS: 2 VSS: 5336 8005 4466 5092 2 DFFX1_HS $T=1058920 485760 1 0 $X=1058740 $Y=481315
X39706 VSS: 2 VSS: 5457 8006 4466 4469 2 DFFX1_HS $T=1053860 485760 0 0 $X=1053680 $Y=485495
X39719 VSS: 2 VSS: 5628 5627 5460 5459 2 NAND3X2_HS $T=1063520 494040 0 0 $X=1063340 $Y=493775
X39729 VSS: 2 VSS: 5629 5190 5461 5458 5144 2 AOI22X2 $T=1064440 502320 1 0 $X=1064260 $Y=497875
X39730 VSS: 2 VSS: 5425 4401 2 CLKBUFX4 $T=1052020 502320 0 0 $X=1051840 $Y=502055
X39731 VSS: 2 VSS: 5460 4207 5461 5458 5337 2 AOI22X2_HS $T=1060300 502320 1 180 $X=1054600 $Y=502055
X39739 VSS: 2 VSS: 5458 8007 4466 5224 2 DFFX1_HS $T=1056160 510600 1 0 $X=1055980 $Y=506155
X39743 VSS: 2 VSS: 5456 5462 2312 2311 5464 2 AOI22X1 $T=1056160 510600 1 180 $X=1053220 $Y=510335
X39745 VSS: 2 VSS: 4621 5463 2 CLKBUFX8 $T=1058000 510600 0 0 $X=1057820 $Y=510335
X39753 VSS: 2 VSS: 5464 8008 4466 4967 2 DFFX1_HS $T=1058460 518880 1 0 $X=1058280 $Y=514435
X39755 VSS: 2 VSS: 5459 5339 5466 2 AND2X1_HS $T=1049260 518880 0 0 $X=1049080 $Y=518615
X39756 VSS: 2 VSS: 5466 3756 5465 5462 3491 2 AOI22X1_HS $T=1052020 518880 0 0 $X=1051840 $Y=518615
X39767 VSS: 2 VSS: 5633 7208 3904 5096 2 DFFX4_HS $T=1060760 527160 1 0 $X=1060580 $Y=522715
X39770 VSS: 2 VSS: 5461 8009 4466 5102 2 DFFX1_HS $T=1053400 527160 0 0 $X=1053220 $Y=526895
X39771 VSS: 2 VSS: 5102 5425 2 CLKBUFX4 $T=1062600 527160 0 0 $X=1062420 $Y=526895
X39776 VSS: 2 VSS: 5462 8010 4466 4968 2 DFFX1_HS $T=1049260 535440 1 0 $X=1049080 $Y=530995
X39801 VSS: 2 VSS: 5467 7209 3904 5224 2 DFFX4_HS $T=1050640 552000 1 0 $X=1050460 $Y=547555
X39808 VSS: 2 VSS: 5469 7210 2945 5102 2 DFFX4_HS $T=1060760 552000 0 0 $X=1060580 $Y=551735
X39817 VSS: 2 VSS: 5644 7211 2945 5642 2 DFFX4_HS $T=1063980 560280 1 0 $X=1063800 $Y=555835
X39821 VSS: 2 VSS: 5468 7212 2945 5105 2 DFFX4_HS $T=1052480 560280 0 0 $X=1052300 $Y=560015
X39830 VSS: 2 VSS: 5470 3541 5469 5342 3313 2 AOI22X1_HS $T=1062140 568560 1 0 $X=1061960 $Y=564115
X39841 VSS: 2 VSS: 5646 5190 5144 5342 5469 2 AOI22X2_HS $T=1063520 576840 1 0 $X=1063340 $Y=572395
X39845 VSS: 2 VSS: 5472 7213 3904 5056 2 DFFX4_HS $T=1052020 576840 0 0 $X=1051840 $Y=576575
X39850 VSS: 2 VSS: 5347 7214 2945 5056 2 DFFX4_HS $T=1049720 585120 1 0 $X=1049540 $Y=580675
X39856 VSS: 2 VSS: 5473 5469 2006 2007 5347 2 AOI22X1 $T=1057540 585120 0 0 $X=1057360 $Y=584855
X39884 VSS: 2 VSS: 5351 4987 5475 5474 4986 2 AOI22X2_HS $T=1050640 609960 1 0 $X=1050460 $Y=605515
X39889 VSS: 2 VSS: 5353 3810 5475 5474 4296 2 AOI22X2_HS $T=1049260 609960 0 0 $X=1049080 $Y=609695
X39901 VSS: 2 VSS: 5476 5474 2013 2012 5352 2 AOI22X1 $T=1062140 618240 1 0 $X=1061960 $Y=613795
X39951 VSS: 2 VSS: 5478 5312 5477 2 AND2X1_HS $T=1071340 13800 0 0 $X=1071160 $Y=13535
X39959 VSS: 2 VSS: 2604 5669 2 BUFX16_HS $T=1086520 22080 0 180 $X=1076220 $Y=17635
X39962 VSS: 2 VSS: 5477 5479 5162 2 NAND2X2 $T=1073180 22080 1 180 $X=1070700 $Y=21815
X39982 VSS: 2 VSS: 5480 5274 5273 5365 5318 2 AOI22X2 $T=1067660 38640 0 0 $X=1067480 $Y=38375
X39989 VSS: 2 VSS: 5481 5482 5478 2 NAND2X4_HS $T=1075020 46920 1 0 $X=1074840 $Y=42475
X39999 VSS: 2 VSS: 5483 4834 2 BUFX4_HS $T=1078700 55200 1 0 $X=1078520 $Y=50755
X40006 VSS: 2 VSS: 5007 8011 2627 5484 2 DFFX1_HS $T=1072260 63480 1 0 $X=1072080 $Y=59035
X40009 VSS: 2 VSS: 4907 8012 2677 5484 2 DFFX1_HS $T=1070420 63480 0 0 $X=1070240 $Y=63215
X40018 VSS: 2 VSS: 5486 4948 2 CLKBUFX4 $T=1078240 71760 0 0 $X=1078060 $Y=71495
X40020 VSS: 2 VSS: 5479 8013 4463 5487 2 DFFX1_HS $T=1081460 71760 0 0 $X=1081280 $Y=71495
X40023 VSS: 2 VSS: 5128 8014 2627 5487 2 DFFX1_HS $T=1071800 80040 1 0 $X=1071620 $Y=75595
X40027 VSS: 2 VSS: 5079 8015 2677 5487 2 DFFX1_HS $T=1070880 80040 0 0 $X=1070700 $Y=79775
X40029 VSS: 2 VSS: 5488 5323 2606 2808 5369 2 AOI22X1 $T=1068120 88320 0 180 $X=1065180 $Y=83875
X40041 VSS: 2 VSS: 5489 5369 5490 5273 5274 2 AOI22X1_HS $T=1067660 96600 1 0 $X=1067480 $Y=92155
X40046 VSS: 2 VSS: 5491 3828 5369 5490 4336 2 AOI22X2 $T=1068120 96600 0 0 $X=1067940 $Y=96335
X40051 VSS: 2 VSS: 5361 7215 4461 5370 2 DFFX4_HS $T=1066740 104880 1 0 $X=1066560 $Y=100435
X40058 VSS: 2 VSS: 5492 7216 4396 5487 2 DFFX4_HS $T=1069960 113160 1 0 $X=1069780 $Y=108715
X40066 VSS: 2 VSS: 5495 3828 5371 5494 4336 2 AOI22X2 $T=1073180 121440 1 0 $X=1073000 $Y=116995
X40071 VSS: 2 VSS: 5494 7217 4530 5370 2 DFFX4_HS $T=1070880 121440 0 0 $X=1070700 $Y=121175
X40076 VSS: 2 VSS: 5499 5496 5498 5330 5497 2 NAND4X2_HS $T=1065360 129720 0 0 $X=1065180 $Y=129455
X40087 VSS: 2 VSS: 5498 5501 5502 2 NAND2X2 $T=1078240 138000 1 180 $X=1075760 $Y=137735
X40089 VSS: 2 VSS: 5503 5180 2 INVX8_HS $T=1070420 146280 0 180 $X=1065180 $Y=141835
X40093 VSS: 2 VSS: 5501 7218 4530 5487 2 DFFX4_HS $T=1078240 146280 1 0 $X=1078060 $Y=141835
X40096 VSS: 2 VSS: 5504 8016 4331 5487 2 DFFX1_HS $T=1070880 146280 0 0 $X=1070700 $Y=146015
X40100 VSS: 2 VSS: 5506 5180 2 INVX2_HS $T=1069500 154560 1 0 $X=1069320 $Y=150115
X40108 VSS: 2 VSS: 5507 5504 5502 2 NAND2X1 $T=1079620 154560 0 0 $X=1079440 $Y=154295
X40113 VSS: 2 VSS: 5493 5375 5508 5507 5509 2 NAND4X2_HS $T=1074560 162840 1 0 $X=1074380 $Y=158395
X40119 VSS: 2 VSS: 5508 5377 5485 5273 5274 2 AOI22X1_HS $T=1078700 162840 1 180 $X=1075300 $Y=162575
X40125 VSS: 2 VSS: 5510 5511 5335 5505 5703 2 NAND4X4_HS $T=1075480 171120 1 0 $X=1075300 $Y=166675
X40128 VSS: 2 VSS: 5511 3828 5377 5485 4336 2 AOI22X2 $T=1078700 171120 1 180 $X=1073920 $Y=170855
X40132 VSS: 2 VSS: 5513 5512 5502 2 NAND2X1 $T=1077320 179400 0 180 $X=1075300 $Y=174955
X40136 VSS: 2 VSS: 5516 5513 5514 5515 5380 2 NAND4X2_HS $T=1072720 179400 1 180 $X=1067020 $Y=179135
X40144 VSS: 2 VSS: 5512 8017 4964 5487 2 DFFX1_HS $T=1078700 187680 1 0 $X=1078520 $Y=183235
X40147 VSS: 2 VSS: 5517 8018 4964 5322 2 DFFX1_HS $T=1067200 187680 0 0 $X=1067020 $Y=187415
X40157 VSS: 2 VSS: 5518 5378 2606 2808 5517 2 AOI22X1 $T=1074560 195960 1 180 $X=1071620 $Y=195695
X40160 VSS: 2 VSS: 5522 5382 5378 5379 2595 2 AOI22X1 $T=1068120 204240 0 180 $X=1065180 $Y=199795
X40165 VSS: 2 VSS: 5520 5519 5521 5522 2 NAND3X2_HS $T=1077780 204240 1 0 $X=1077600 $Y=199795
X40168 VSS: 2 VSS: 5521 5383 5517 5381 5523 2 AOI22X2_HS $T=1078700 204240 1 180 $X=1073000 $Y=203975
X40173 VSS: 2 VSS: 5524 5516 5525 2 NOR2X2_HS $T=1079620 212520 0 180 $X=1076220 $Y=208075
X40175 VSS: 2 VSS: 2919 5526 2 BUFX16_HS $T=1075940 212520 1 180 $X=1065640 $Y=212255
X40183 VSS: 2 VSS: 5384 5712 2 CLKBUFX2 $T=1083760 220800 0 180 $X=1081280 $Y=216355
X40188 VSS: 2 VSS: 5527 3424 5528 5387 5713 2 AOI22X2_HS $T=1079160 220800 0 0 $X=1078980 $Y=220535
X40189 VSS: 2 VSS: 5385 4609 2 CLKBUFX8 $T=1072260 229080 0 180 $X=1067020 $Y=224635
X40196 VSS: 2 VSS: 5525 5530 5532 5529 5531 2 NAND4X2_HS $T=1075940 229080 1 180 $X=1070240 $Y=228815
X40198 VSS: 2 VSS: 5533 4457 2 CLKBUFX2 $T=1077780 229080 0 0 $X=1077600 $Y=228815
X40199 VSS: 2 VSS: 5710 8019 4964 5533 2 DFFX1_HS $T=1080080 229080 0 0 $X=1079900 $Y=228815
X40202 VSS: 2 VSS: 5532 5534 5388 5256 5016 2 AOI22X1 $T=1069960 237360 1 0 $X=1069780 $Y=232915
X40208 VSS: 2 VSS: 5536 5535 5520 2 NOR2X2_HS $T=1074100 237360 0 0 $X=1073920 $Y=237095
X40214 VSS: 2 VSS: 5539 5538 5388 5534 5537 2 AOI22X1_HS $T=1071800 245640 1 0 $X=1071620 $Y=241195
X40220 VSS: 2 VSS: 5535 5541 5540 5539 5527 2 NAND4X2_HS $T=1073180 245640 0 0 $X=1073000 $Y=245375
X40224 VSS: 2 VSS: 5531 5506 5419 5392 5500 2 AOI22X2 $T=1067660 253920 1 0 $X=1067480 $Y=249475
X40230 VSS: 2 VSS: 5542 5543 5391 2568 2 AOI21X1 $T=1069960 253920 0 0 $X=1069780 $Y=253655
X40237 VSS: 2 VSS: 5544 4927 5543 5404 4374 2 AOI22X1_HS $T=1072720 262200 1 0 $X=1072540 $Y=257755
X40241 VSS: 2 VSS: 5545 5408 5543 5404 3496 2 AOI22X1_HS $T=1069500 262200 1 180 $X=1066100 $Y=261935
X40242 VSS: 2 VSS: 4609 4966 2 CLKBUFX8 $T=1069500 262200 0 0 $X=1069320 $Y=261935
X40246 VSS: 2 VSS: 5394 5546 5536 2 NAND2X2_HS $T=1081000 262200 1 180 $X=1077600 $Y=261935
X40248 VSS: 2 VSS: 5400 8020 1824 5385 2 DFFX1_HS $T=1066740 270480 1 0 $X=1066560 $Y=266035
X40251 VSS: 2 VSS: 5722 8021 1824 5533 2 DFFX1_HS $T=1080080 270480 1 0 $X=1079900 $Y=266035
X40254 VSS: 2 VSS: 5548 5549 5552 2 AND2X1_HS $T=1071800 270480 0 0 $X=1071620 $Y=270215
X40255 VSS: 2 VSS: 5552 5288 5551 5550 5208 2 AOI22X2_HS $T=1074560 270480 0 0 $X=1074380 $Y=270215
X40261 VSS: 2 VSS: 5554 5548 5553 5547 2 NAND3X2_HS $T=1078700 278760 0 180 $X=1073920 $Y=274315
X40264 VSS: 2 VSS: 5397 5555 5556 2 NOR2X2_HS $T=1067660 278760 0 0 $X=1067480 $Y=278495
X40268 VSS: 2 VSS: 5557 5256 5401 5564 5016 2 AOI22X1 $T=1080080 278760 0 0 $X=1079900 $Y=278495
X40274 VSS: 2 VSS: 5558 4840 5400 5722 4729 2 AOI22X1 $T=1081000 287040 1 0 $X=1080820 $Y=282595
X40279 VSS: 2 VSS: 5559 5506 5561 5562 5500 2 AOI22X2_HS $T=1065360 295320 1 0 $X=1065180 $Y=290875
X40280 VSS: 2 VSS: 4573 5560 2 CLKBUFX8 $T=1075940 295320 0 180 $X=1070700 $Y=290875
X40288 VSS: 2 VSS: 5565 5538 5401 5564 5537 2 AOI22X1_HS $T=1077320 295320 0 0 $X=1077140 $Y=295055
X40294 VSS: 2 VSS: 5566 3855 5562 5561 5563 2 AOI22X1_HS $T=1079620 303600 1 0 $X=1079440 $Y=299155
X40300 VSS: 2 VSS: 5568 5567 5565 5566 5726 2 NAND4X2_HS $T=1080080 303600 0 0 $X=1079900 $Y=303335
X40314 VSS: 2 VSS: 5727 8022 4964 5023 2 DFFX1_HS $T=1076860 320160 1 0 $X=1076680 $Y=315715
X40315 VSS: 2 VSS: 5409 5570 5571 5026 5025 2 AOI22X1 $T=1069960 320160 1 180 $X=1067020 $Y=319895
X40324 VSS: 2 VSS: 5572 4374 5411 5405 4927 2 AOI22X1_HS $T=1082380 328440 0 180 $X=1078980 $Y=323995
X40326 VSS: 2 VSS: 5570 8023 1824 5023 2 DFFX1_HS $T=1068580 328440 0 0 $X=1068400 $Y=328175
X40330 VSS: 2 VSS: 5417 5575 5574 5573 2 ICGPRECX1 $T=1075020 336720 0 180 $X=1066100 $Y=332275
X40337 VSS: 2 VSS: 5734 5735 5568 2 NOR2X2_HS $T=1083760 336720 1 180 $X=1080360 $Y=336455
X40341 VSS: 2 VSS: 5418 5578 5577 5576 2 ICGPRECX1 $T=1078700 345000 0 180 $X=1069780 $Y=340555
X40344 VSS: 2 VSS: 5579 3305 3149 2 AND2X1 $T=1083300 345000 0 180 $X=1080820 $Y=340555
X40346 VSS: 2 VSS: 5575 2 TIELO $T=1076400 345000 1 180 $X=1074840 $Y=344735
X40352 VSS: 2 VSS: 5407 5581 5430 5580 2 ICGPRECX1 $T=1080080 353280 0 180 $X=1071160 $Y=348835
X40358 VSS: 2 VSS: 5582 5579 2287 2 NAND2X4_HS $T=1077780 353280 0 0 $X=1077600 $Y=353015
X40364 VSS: 2 VSS: 5583 5592 5430 5587 2 ICGPRECX1 $T=1086060 361560 0 180 $X=1077140 $Y=357115
X40365 VSS: 2 VSS: 5422 424 2 INVX4 $T=1065820 361560 0 0 $X=1065640 $Y=361295
X40366 VSS: 2 VSS: 5573 5443 5422 5582 2 OAI21X1_HS $T=1068120 361560 0 0 $X=1067940 $Y=361295
X40371 VSS: 2 VSS: 5576 5740 5422 5582 2 OAI21X1_HS $T=1083760 361560 1 180 $X=1080820 $Y=361295
X40374 VSS: 2 VSS: 5096 5584 2 CLKBUFX4 $T=1070420 369840 0 180 $X=1067480 $Y=365395
X40380 VSS: 2 VSS: 5585 5743 5574 5741 2 ICGPRECX1 $T=1089740 369840 0 180 $X=1080820 $Y=365395
X40385 VSS: 2 VSS: 5580 5423 5422 5582 2 OAI21X1_HS $T=1075940 369840 0 0 $X=1075760 $Y=369575
X40388 VSS: 2 VSS: 5420 5427 5577 5424 2 ICGPRECX1 $T=1076400 378120 0 180 $X=1067480 $Y=373675
X40393 VSS: 2 VSS: 5581 2 TIELO $T=1071340 378120 0 0 $X=1071160 $Y=377855
X40397 VSS: 2 VSS: 5586 2 TIELO $T=1078700 378120 0 0 $X=1078520 $Y=377855
X40399 VSS: 2 VSS: 5578 2 TIELO $T=1066740 386400 0 180 $X=1065180 $Y=381955
X40402 VSS: 2 VSS: 5584 4218 2 CLKBUFX4 $T=1070880 386400 1 0 $X=1070700 $Y=381955
X40406 VSS: 2 VSS: 5588 5586 5574 5748 2 ICGPRECX1 $T=1088360 386400 0 180 $X=1079440 $Y=381955
X40408 VSS: 2 VSS: 5428 5438 5422 5582 2 OAI21X1_HS $T=1066280 386400 0 0 $X=1066100 $Y=386135
X40409 VSS: 2 VSS: 5589 5442 5422 5582 2 OAI21X1_HS $T=1069040 386400 0 0 $X=1068860 $Y=386135
X40414 VSS: 2 VSS: 4218 5591 2 CLKBUFX8 $T=1073640 394680 0 180 $X=1068400 $Y=390235
X40416 VSS: 2 VSS: 4966 5585 2 CLKBUFX8 $T=1080540 394680 0 180 $X=1075300 $Y=390235
X40419 VSS: 2 VSS: 5587 5593 5422 5582 2 OAI21X1_HS $T=1069960 394680 1 180 $X=1067020 $Y=394415
X40426 VSS: 2 VSS: 5450 5596 clk_i 5594 2 ICGPRECX1 $T=1080540 402960 0 180 $X=1071620 $Y=398515
X40427 VSS: 2 VSS: 5596 2 TIELO $T=1081920 402960 0 180 $X=1080360 $Y=398515
X40429 VSS: 2 VSS: 5597 5438 5422 5421 2 OAI21X1_HS $T=1070420 402960 1 180 $X=1067480 $Y=402695
X40437 VSS: 2 VSS: 5440 5434 5430 5589 2 ICGPRECX1 $T=1077320 411240 0 180 $X=1068400 $Y=406795
X40438 VSS: 2 VSS: 5594 5443 5422 5421 2 OAI21X1_HS $T=1077320 411240 1 0 $X=1077140 $Y=406795
X40443 VSS: 2 VSS: 5598 2 TIELO $T=1075020 411240 1 180 $X=1073460 $Y=410975
X40448 VSS: 2 VSS: 5592 2 TIELO $T=1069500 419520 1 0 $X=1069320 $Y=415075
X40450 VSS: 2 VSS: 5020 5588 2 CLKBUFX4 $T=1074100 419520 0 180 $X=1071160 $Y=415075
X40452 VSS: 2 VSS: 5599 5583 2 CLKBUFX2 $T=1077320 419520 0 180 $X=1074840 $Y=415075
X40454 VSS: 2 VSS: 5600 2 TIELO $T=1079160 419520 1 0 $X=1078980 $Y=415075
X40462 VSS: 2 VSS: 5167 4859 2 CLKBUFX8 $T=1066740 427800 1 0 $X=1066560 $Y=423355
X40465 VSS: 2 VSS: 5593 3319 5602 3321 2 NAND3X1 $T=1073180 427800 1 0 $X=1073000 $Y=423355
X40467 VSS: 2 VSS: 5146 5601 2 CLKBUFX4 $T=1081920 427800 0 180 $X=1078980 $Y=423355
X40472 VSS: 2 VSS: 5423 5441 5602 2 OR2X2 $T=1074560 427800 0 0 $X=1074380 $Y=427535
X40476 VSS: 2 VSS: 5602 3320 2 CLKINVX2 $T=1070420 436080 1 0 $X=1070240 $Y=431635
X40477 VSS: 2 VSS: 5605 5599 2 CLKBUFX2 $T=1074100 436080 0 180 $X=1071620 $Y=431635
X40483 VSS: 2 VSS: 1306 5606 2 BUFX16_HS $T=1078700 436080 1 180 $X=1068400 $Y=435815
X40485 VSS: 2 VSS: 5445 3319 3320 2 NOR2X1 $T=1071340 444360 0 180 $X=1069320 $Y=439915
X40488 VSS: 2 VSS: 5604 5448 5430 5603 2 ICGPRECX1 $T=1081460 444360 0 180 $X=1072540 $Y=439915
X40492 VSS: 2 VSS: 5606 5609 5610 2 NAND2X2_HS $T=1077320 444360 1 180 $X=1073920 $Y=444095
X40493 VSS: 2 VSS: 5609 5608 5607 2 NOR2X2_HS $T=1077320 444360 0 0 $X=1077140 $Y=444095
X40499 VSS: 2 VSS: 5487 5611 2 CLKBUFX8 $T=1081000 452640 0 180 $X=1075760 $Y=448195
X40502 VSS: 2 VSS: 5611 5605 2 CLKBUFX2 $T=1069040 452640 0 0 $X=1068860 $Y=452375
X40506 VSS: 2 VSS: 5610 5612 5613 2 NOR2X2_HS $T=1074560 452640 0 0 $X=1074380 $Y=452375
X40508 VSS: 2 VSS: 5772 5461 2006 2007 5452 2 AOI22X1 $T=1081460 452640 0 0 $X=1081280 $Y=452375
X40513 VSS: 2 VSS: 5615 5611 2 CLKBUFX4 $T=1082380 460920 0 180 $X=1079440 $Y=456475
X40515 VSS: 2 VSS: 5616 4927 5451 5452 4374 2 AOI22X1_HS $T=1073180 460920 0 0 $X=1073000 $Y=460655
X40519 VSS: 2 VSS: 5454 4509 2 CLKBUFX4 $T=1070420 469200 0 180 $X=1067480 $Y=464755
X40521 VSS: 2 VSS: 5618 5447 2 CLKBUFX4 $T=1075020 469200 0 180 $X=1072080 $Y=464755
X40522 VSS: 2 VSS: 5617 5619 5620 5026 5025 2 AOI22X1 $T=1077780 469200 0 180 $X=1074840 $Y=464755
X40525 VSS: 2 VSS: 4403 5778 2 CLKBUFX8 $T=1085140 469200 0 180 $X=1079900 $Y=464755
X40527 VSS: 2 VSS: 5621 5451 5455 2568 2 AOI21X1 $T=1070880 469200 1 180 $X=1068400 $Y=468935
X40531 VSS: 2 VSS: 5619 8024 4466 5023 2 DFFX1_HS $T=1068120 477480 1 0 $X=1067940 $Y=473035
X40533 VSS: 2 VSS: 5623 5622 2 CLKBUFX2 $T=1080080 477480 0 180 $X=1077600 $Y=473035
X40535 VSS: 2 VSS: 5023 4610 2 CLKBUFX8 $T=1066280 477480 0 0 $X=1066100 $Y=477215
X40538 VSS: 2 VSS: 1606 5624 2 BUFX16_HS $T=1082840 477480 1 180 $X=1072540 $Y=477215
X40541 VSS: 2 VSS: 4812 5611 2 CLKBUFX8 $T=1080540 485760 0 180 $X=1075300 $Y=481315
X40546 VSS: 2 VSS: 5625 5457 2785 2796 5458 2 AOI22X1 $T=1069960 485760 0 0 $X=1069780 $Y=485495
X40551 VSS: 2 VSS: 5627 5537 5626 5464 5538 2 AOI22X2_HS $T=1067200 494040 1 0 $X=1067020 $Y=489595
X40571 VSS: 2 VSS: 5608 5632 5630 5631 5629 2 NAND4X2_HS $T=1080540 510600 0 180 $X=1074840 $Y=506155
X40576 VSS: 2 VSS: 5631 5336 5104 5103 5338 2 AOI22X1 $T=1074560 510600 0 0 $X=1074380 $Y=510335
X40583 VSS: 2 VSS: 5630 5626 5464 3620 5016 2 AOI22X1_HS $T=1077780 518880 1 0 $X=1077600 $Y=514435
X40590 VSS: 2 VSS: 5632 4840 5462 5465 4729 2 AOI22X1 $T=1078700 518880 0 0 $X=1078520 $Y=518615
X40598 VSS: 2 VSS: 5635 5340 5634 2568 2 AOI21X1 $T=1073180 527160 0 0 $X=1073000 $Y=526895
X40605 VSS: 2 VSS: 5634 5636 4699 2 NAND2X1 $T=1080540 535440 0 180 $X=1078520 $Y=530995
X40615 VSS: 2 VSS: rdata_o[21] 5640 5639 5638 5635 2 NAND4X1 $T=1072720 543720 1 0 $X=1072540 $Y=539275
X40619 VSS: 2 VSS: 5640 4378 2785 2796 5342 2 AOI22X1 $T=1066280 543720 0 0 $X=1066100 $Y=543455
X40628 VSS: 2 VSS: 5638 4345 2991 2992 5641 2 AOI22X1 $T=1075480 552000 0 180 $X=1072540 $Y=547555
X40648 VSS: 2 VSS: 5645 5470 5643 2 AND2X1_HS $T=1077320 568560 0 0 $X=1077140 $Y=568295
X40657 VSS: 2 VSS: 5794 7219 2945 5647 2 DFFX4_HS $T=1073640 576840 0 0 $X=1073460 $Y=576575
X40669 VSS: 2 VSS: 5348 7220 2945 4759 2 DFFX4_HS $T=1070880 593400 1 0 $X=1070700 $Y=588955
X40673 VSS: 2 VSS: 5648 5468 5649 5104 5103 2 AOI22X2_HS $T=1074100 593400 0 0 $X=1073920 $Y=593135
X40680 VSS: 2 VSS: 5651 5468 1695 1716 5357 2 AOI22X1 $T=1076860 601680 1 0 $X=1076680 $Y=597235
X40687 VSS: 2 VSS: 5654 5349 5653 5272 5652 2 NAND4X1 $T=1075940 601680 0 0 $X=1075760 $Y=601415
X40697 VSS: 2 VSS: 5639 5654 5655 5656 2 NOR3X1 $T=1078240 609960 1 180 $X=1075760 $Y=609695
X40707 VSS: 2 VSS: 5658 5650 5657 2 NAND2X4_HS $T=1082380 618240 1 180 $X=1077140 $Y=617975
X40711 VSS: 2 VSS: 5655 5476 5660 5473 5659 2 NAND4X1 $T=1075480 626520 1 0 $X=1075300 $Y=622075
X40717 VSS: 2 VSS: 5659 5644 3022 3205 4228 2 AOI22X1 $T=1075940 626520 0 0 $X=1075760 $Y=626255
X40720 VSS: 2 VSS: 5064 5661 5658 2 NOR2X4_HS $T=1069500 634800 1 0 $X=1069320 $Y=630355
X40726 VSS: 2 VSS: 5236 5662 5663 2 NOR2X4_HS $T=1076400 634800 0 0 $X=1076220 $Y=634535
X40728 VSS: 2 VSS: 5664 5199 2 INVX4 $T=1065820 643080 1 0 $X=1065640 $Y=638635
X40737 VSS: 2 VSS: 5665 5480 5668 5667 5311 2 NAND4X4_HS $T=1094800 13800 0 180 $X=1085880 $Y=9355
X40746 VSS: 2 VSS: 5667 5479 5313 2 NAND2X1 $T=1088360 13800 0 0 $X=1088180 $Y=13535
X40763 VSS: 2 VSS: 5671 5670 5162 2 NAND2X1 $T=1089280 22080 0 0 $X=1089100 $Y=21815
X40769 VSS: 2 VSS: 5666 5672 5671 5317 5360 2 NAND4X4_HS $T=1091580 30360 0 180 $X=1082660 $Y=25915
X40776 VSS: 2 VSS: 5674 7221 4461 4111 2 DFFX4_HS $T=1082380 30360 0 0 $X=1082200 $Y=30095
X40783 VSS: 2 VSS: 5672 4179 5676 5677 3461 2 AOI22X1_HS $T=1085600 38640 1 0 $X=1085420 $Y=34195
X40785 VSS: 2 VSS: 4111 5675 2 CLKBUFX8 $T=1097560 38640 0 180 $X=1092320 $Y=34195
X40794 VSS: 2 VSS: 5363 4179 5678 5679 3461 2 AOI22X1_HS $T=1098020 38640 1 180 $X=1094620 $Y=38375
X40802 VSS: 2 VSS: 5668 5679 5678 5280 5483 2 AOI22X1_HS $T=1098940 46920 0 180 $X=1095540 $Y=42475
X40809 VSS: 2 VSS: 5673 5483 5677 5676 5280 2 AOI22X2_HS $T=1093880 46920 1 180 $X=1088180 $Y=46655
X40823 VSS: 2 VSS: 5676 7222 4461 5366 2 DFFX4_HS $T=1082380 55200 0 0 $X=1082200 $Y=54935
X40833 VSS: 2 VSS: 5678 8025 4463 5366 2 DFFX1_HS $T=1094340 63480 1 0 $X=1094160 $Y=59035
X40838 VSS: 2 VSS: 5679 8026 4463 5367 2 DFFX1_HS $T=1086980 63480 0 0 $X=1086800 $Y=63215
X40845 VSS: 2 VSS: 5677 7223 4461 5367 2 DFFX4_HS $T=1084220 71760 1 0 $X=1084040 $Y=67315
X40853 VSS: 2 VSS: 5684 7224 4396 5367 2 DFFX4_HS $T=1095720 71760 0 0 $X=1095540 $Y=71495
X40866 VSS: 2 VSS: 5680 7225 4396 5366 2 DFFX4_HS $T=1091120 80040 0 0 $X=1090940 $Y=79775
X40870 VSS: 2 VSS: 5670 7226 4461 5487 2 DFFX4_HS $T=1081920 88320 1 0 $X=1081740 $Y=83875
X40878 VSS: 2 VSS: 5683 5489 5324 5681 5682 2 NAND4X2_HS $T=1082840 88320 0 0 $X=1082660 $Y=88055
X40890 VSS: 2 VSS: 5682 5684 5680 5280 5483 2 AOI22X1_HS $T=1092500 96600 1 0 $X=1092320 $Y=92155
X40900 VSS: 2 VSS: 5686 5683 5685 2 NOR2X2_HS $T=1090660 96600 0 0 $X=1090480 $Y=96335
X40910 VSS: 2 VSS: 5687 3461 5684 5680 4179 2 AOI22X2_HS $T=1092040 104880 1 0 $X=1091860 $Y=100435
X40917 VSS: 2 VSS: 5688 5326 5491 5687 5689 2 NAND4X4_HS $T=1086520 104880 0 0 $X=1086340 $Y=104615
X40924 VSS: 2 VSS: 5689 5492 5162 2 NAND2X2 $T=1090660 113160 1 0 $X=1090480 $Y=108715
X40932 VSS: 2 VSS: 5681 5492 5502 2 NAND2X2 $T=1088360 113160 0 0 $X=1088180 $Y=112895
X40945 VSS: 2 VSS: 5370 5691 2 CLKBUFX2 $T=1082380 121440 0 0 $X=1082200 $Y=121175
X40947 VSS: 2 VSS: 5502 5253 2 CLKBUFX2_HS $T=1085140 121440 0 0 $X=1084960 $Y=121175
X40951 VSS: 2 VSS: 5695 7227 4530 5367 2 DFFX4_HS $T=1091580 121440 0 0 $X=1091400 $Y=121175
X40957 VSS: 2 VSS: 5692 5329 5495 5693 5694 2 NAND4X4_HS $T=1097560 129720 0 180 $X=1088640 $Y=125275
X40967 VSS: 2 VSS: 5497 5483 5695 5690 5280 2 AOI22X2_HS $T=1097100 129720 1 180 $X=1091400 $Y=129455
X40975 VSS: 2 VSS: 5694 5501 5162 2 NAND2X2 $T=1085600 138000 1 0 $X=1085420 $Y=133555
X40980 VSS: 2 VSS: 5690 7228 4530 5366 2 DFFX4_HS $T=1096640 138000 1 0 $X=1096460 $Y=133555
X40989 VSS: 2 VSS: 5696 5499 5697 2 NOR2X4_HS $T=1093420 138000 0 0 $X=1093240 $Y=137735
X40995 VSS: 2 VSS: 5292 5696 5698 2 NAND2X2_HS $T=1095260 146280 1 0 $X=1095080 $Y=141835
X41003 VSS: 2 VSS: 5505 5504 5162 2 NAND2X2_HS $T=1090660 146280 0 0 $X=1090480 $Y=146015
X41004 VSS: 2 VSS: 5089 5699 2 CLKBUFX4 $T=1093880 146280 0 0 $X=1093700 $Y=146015
X41011 VSS: 2 VSS: 5700 4729 2 BUFX16_HS $T=1085600 154560 1 0 $X=1085420 $Y=150115
X41019 VSS: 2 VSS: 5701 8027 4331 5367 2 DFFX1_HS $T=1090200 154560 0 0 $X=1090020 $Y=154295
X41027 VSS: 2 VSS: 5509 5701 5702 5280 5483 2 AOI22X1 $T=1096180 162840 0 180 $X=1093240 $Y=158395
X41051 VSS: 2 VSS: 4429 5704 2 CLKBUFX8 $T=1090200 171120 0 0 $X=1090020 $Y=170855
X41059 VSS: 2 VSS: 5514 5483 5705 5706 4885 2 AOI22X1_HS $T=1092960 179400 1 0 $X=1092780 $Y=174955
X41069 VSS: 2 VSS: 5706 8028 4964 5366 2 DFFX1_HS $T=1093420 179400 0 0 $X=1093240 $Y=179135
X41075 VSS: 2 VSS: 5705 8029 4964 5367 2 DFFX1_HS $T=1095260 187680 1 0 $X=1095080 $Y=183235
X41082 VSS: 2 VSS: 5707 4885 2 BUFX8_HS $T=1092500 187680 1 180 $X=1086800 $Y=187415
X41083 VSS: 2 VSS: 5366 5021 2 CLKBUFX4 $T=1092500 187680 0 0 $X=1092320 $Y=187415
X41092 VSS: 2 VSS: 5708 3840 5705 5706 5821 2 AOI22X2_HS $T=1094800 195960 1 0 $X=1094620 $Y=191515
X41099 VSS: 2 VSS: 5519 5709 5708 2 AND2X1_HS $T=1091120 195960 1 180 $X=1088180 $Y=195695
X41100 VSS: 2 VSS: 5021 4087 2 CLKBUFX8 $T=1091120 195960 0 0 $X=1090940 $Y=195695
X41110 VSS: 2 VSS: 5824 5826 1991 1990 5706 2 AOI22X1 $T=1097560 204240 1 0 $X=1097380 $Y=199795
X41120 VSS: 2 VSS: 5827 5512 1701 1726 5710 2 AOI22X1 $T=1096640 204240 0 0 $X=1096460 $Y=203975
X41129 VSS: 2 VSS: 5709 5512 3843 2 NAND2X2 $T=1095260 212520 0 180 $X=1092780 $Y=208075
X41135 VSS: 2 VSS: 5526 5711 5524 2 NAND2X2_HS $T=1087440 212520 1 180 $X=1084040 $Y=212255
X41146 VSS: 2 VSS: 5523 4338 2 CLKBUFX2_HS $T=1090200 220800 0 180 $X=1086800 $Y=216355
X41161 VSS: 2 VSS: 5530 5700 5710 5386 5251 2 AOI22X2 $T=1083760 229080 1 0 $X=1083580 $Y=224635
X41169 VSS: 2 VSS: 5534 8030 4964 5714 2 DFFX1_HS $T=1089740 229080 0 0 $X=1089560 $Y=228815
X41174 VSS: 2 VSS: 5540 3756 5710 5386 5715 2 AOI22X2_HS $T=1082840 237360 1 0 $X=1082660 $Y=232915
X41182 VSS: 2 VSS: 5714 4651 2 CLKBUFX8 $T=1088360 237360 0 0 $X=1088180 $Y=237095
X41183 VSS: 2 VSS: 5717 5716 2991 2992 5534 2 AOI22X1 $T=1093420 237360 0 0 $X=1093240 $Y=237095
X41206 VSS: 2 VSS: 5541 5563 5419 5392 3855 2 AOI22X2_HS $T=1083760 253920 1 0 $X=1083580 $Y=249475
X41214 VSS: 2 VSS: 5718 5392 2006 2007 5404 2 AOI22X1 $T=1085140 253920 0 0 $X=1084960 $Y=253655
X41225 VSS: 2 VSS: 5719 4511 2 CLKBUFX2_HS $T=1091580 262200 1 0 $X=1091400 $Y=257755
X41233 VSS: 2 VSS: 5547 5719 5720 5721 4946 2 AOI22X2 $T=1097100 262200 1 180 $X=1092320 $Y=261935
X41238 VSS: 2 VSS: 5720 8031 1824 5396 2 DFFX1_HS $T=1089280 270480 1 0 $X=1089100 $Y=266035
X41252 VSS: 2 VSS: 5553 5285 4877 5723 5724 2 AOI22X2_HS $T=1092960 278760 0 180 $X=1087260 $Y=274315
X41274 VSS: 2 VSS: 5567 5715 5400 5722 3756 2 AOI22X1_HS $T=1082380 287040 0 0 $X=1082200 $Y=286775
X41279 VSS: 2 VSS: 5725 5720 2991 2992 5564 2 AOI22X1 $T=1100320 287040 1 180 $X=1097380 $Y=286775
X41283 VSS: 2 VSS: 5563 3313 2 BUFX4_HS $T=1086060 295320 0 180 $X=1082200 $Y=290875
X41288 VSS: 2 VSS: 5861 5858 2785 2796 5561 2 AOI22X1 $T=1097560 295320 1 0 $X=1097380 $Y=290875
X41295 VSS: 2 VSS: 5560 clk_i 2 CLKBUFX8 $T=1090200 295320 0 0 $X=1090020 $Y=295055
X41318 VSS: 2 VSS: 5728 5562 2006 2007 5411 2 AOI22X1 $T=1084220 311880 1 0 $X=1084040 $Y=307435
X41328 VSS: 2 VSS: 5569 5729 5730 2 AND2X1_HS $T=1090660 311880 1 180 $X=1087720 $Y=311615
X41342 VSS: 2 VSS: 5732 5731 5572 2 AND2X1_HS $T=1085600 320160 0 0 $X=1085420 $Y=319895
X41358 VSS: 2 VSS: 5412 5733 5734 2 NAND2X2_HS $T=1086520 328440 1 180 $X=1083120 $Y=328175
X41391 VSS: 2 VSS: 5737 2 TIELO $T=1086520 345000 1 180 $X=1084960 $Y=344735
X41397 VSS: 2 VSS: 5736 3149 2 CLKINVX1 $T=1097100 345000 0 0 $X=1096920 $Y=344735
X41402 VSS: 2 VSS: 5738 3305 2 CLKINVX2 $T=1087440 353280 1 0 $X=1087260 $Y=348835
X41405 VSS: 2 VSS: 5574 clk_i 2 CLKBUFX8 $T=1096180 353280 0 180 $X=1090940 $Y=348835
X41420 VSS: 2 VSS: 5739 5746 5574 5882 2 ICGPRECX1 $T=1099400 361560 0 180 $X=1090480 $Y=357115
X41442 VSS: 2 VSS: 5742 5423 5422 5744 2 OAI21X1_HS $T=1092040 369840 0 0 $X=1091860 $Y=369575
X41443 VSS: 2 VSS: 5577 5430 2 CLKBUFX8 $T=1094800 369840 0 0 $X=1094620 $Y=369575
X41448 VSS: 2 VSS: 5622 5739 2 CLKBUFX2 $T=1085140 378120 0 180 $X=1082660 $Y=373675
X41450 VSS: 2 VSS: 5743 2 TIELO $T=1090200 378120 0 180 $X=1088640 $Y=373675
X41451 VSS: 2 VSS: 5260 5745 2 CLKBUFX4 $T=1092960 378120 0 180 $X=1090020 $Y=373675
X41460 VSS: 2 VSS: 5746 2 TIELO $T=1086520 378120 0 0 $X=1086340 $Y=377855
X41465 VSS: 2 VSS: 5430 clk_i 2 CLKBUFX8 $T=1094800 378120 0 0 $X=1094620 $Y=377855
X41476 VSS: 2 VSS: 5748 5747 5422 5582 2 OAI21X1_HS $T=1087440 386400 1 180 $X=1084500 $Y=386135
X41479 VSS: 2 VSS: 5431 5751 5577 5750 2 ICGPRECX1 $T=1091580 386400 0 0 $X=1091400 $Y=386135
X41492 VSS: 2 VSS: 5750 5752 5422 5582 2 OAI21X1_HS $T=1088820 394680 1 180 $X=1085880 $Y=394415
X41496 VSS: 2 VSS: 5590 5432 5577 5597 2 ICGPRECX1 $T=1097100 394680 0 0 $X=1096920 $Y=394415
X41501 VSS: 2 VSS: 5751 2 TIELO $T=1085140 402960 0 180 $X=1083580 $Y=398515
X41502 VSS: 2 VSS: 5591 5749 5574 5753 2 ICGPRECX1 $T=1093880 402960 0 180 $X=1084960 $Y=398515
X41505 VSS: 2 VSS: 5754 2 TIELO $T=1096640 402960 0 180 $X=1095080 $Y=398515
X41522 VSS: 2 VSS: 5755 5438 5422 5744 2 OAI21X1_HS $T=1090660 411240 1 0 $X=1090480 $Y=406795
X41525 VSS: 2 VSS: 5435 5896 5574 5889 2 ICGPRECX1 $T=1106300 411240 0 180 $X=1097380 $Y=406795
X41532 VSS: 2 VSS: 5756 5146 2 CLKBUFX4 $T=1087440 411240 0 0 $X=1087260 $Y=410975
X41541 VSS: 2 VSS: 5740 5759 5758 2 OR2X2 $T=1089740 419520 1 0 $X=1089560 $Y=415075
X41557 VSS: 2 VSS: 5691 4060 2 CLKBUFX4 $T=1085600 427800 0 180 $X=1082660 $Y=423355
X41560 VSS: 2 VSS: 5752 3319 5759 2 OR2X1_HS $T=1088360 427800 1 0 $X=1088180 $Y=423355
X41561 VSS: 2 VSS: 5760 5600 5430 5755 2 ICGPRECX1 $T=1099860 427800 0 180 $X=1090940 $Y=423355
X41566 VSS: 2 VSS: 5759 3320 3321 2 NAND2X1 $T=1086060 427800 0 0 $X=1085880 $Y=427535
X41574 VSS: 2 VSS: 4060 5761 2 CLKBUFX8 $T=1086980 436080 0 180 $X=1081740 $Y=431635
X41575 VSS: 2 VSS: 5747 3319 5762 3320 2 NAND3X1 $T=1089280 436080 0 180 $X=1086800 $Y=431635
X41578 VSS: 2 VSS: 5761 5903 5430 5902 2 ICGPRECX1 $T=1102160 436080 0 180 $X=1093240 $Y=431635
X41585 VSS: 2 VSS: 5441 5758 5762 2 NAND2X1 $T=1087440 436080 1 180 $X=1085420 $Y=435815
X41592 VSS: 2 VSS: 5762 3321 2 CLKINVX2 $T=1083300 444360 1 0 $X=1083120 $Y=439915
X41593 VSS: 2 VSS: 5763 5598 5430 5757 2 ICGPRECX1 $T=1084680 444360 1 0 $X=1084500 $Y=439915
X41594 VSS: 2 VSS: 5758 3319 2 CLKINVX2 $T=1093420 444360 1 0 $X=1093240 $Y=439915
X41596 VSS: 2 VSS: 5764 5754 5430 5895 2 ICGPRECX1 $T=1105380 444360 0 180 $X=1096460 $Y=439915
X41609 VSS: 2 VSS: 5614 5764 2 CLKBUFX4 $T=1085600 452640 0 180 $X=1082660 $Y=448195
X41611 VSS: 2 VSS: 5449 5763 2 CLKBUFX4 $T=1090200 452640 0 180 $X=1087260 $Y=448195
X41614 VSS: 2 VSS: 5769 5767 5766 4133 3190 2 AOI22X1 $T=1095720 452640 0 180 $X=1092780 $Y=448195
X41623 VSS: 2 VSS: 5612 5771 5765 5769 5768 2 NAND4X2_HS $T=1091120 452640 0 0 $X=1090940 $Y=452375
X41624 VSS: 2 VSS: 5209 5770 2 CLKBUFX8 $T=1096640 452640 0 0 $X=1096460 $Y=452375
X41630 VSS: 2 VSS: 4261 5773 2 CLKBUFX8 $T=1089280 460920 0 180 $X=1084040 $Y=456475
X41634 VSS: 2 VSS: 5774 5776 5775 4914 5255 2 AOI22X1_HS $T=1092500 460920 1 0 $X=1092320 $Y=456475
X41641 VSS: 2 VSS: 5613 5777 5617 5453 2 NAND3X2_HS $T=1085140 460920 0 0 $X=1084960 $Y=460655
X41644 VSS: 2 VSS: 5770 5449 2 CLKBUFX2 $T=1095260 460920 0 0 $X=1095080 $Y=460655
X41650 VSS: 2 VSS: 5052 5760 2 CLKBUFX8 $T=1092040 469200 0 180 $X=1086800 $Y=464755
X41659 VSS: 2 VSS: 5779 4929 5776 5775 4617 2 AOI22X1 $T=1090660 469200 1 180 $X=1087720 $Y=468935
X41667 VSS: 2 VSS: 5782 5779 5781 5616 5780 2 NAND4X2_HS $T=1086060 477480 1 0 $X=1085880 $Y=473035
X41681 VSS: 2 VSS: 4610 5623 2 CLKBUFX8 $T=1087440 485760 0 180 $X=1082200 $Y=481315
X41682 VSS: 2 VSS: 5624 5785 5784 2 NAND2X2_HS $T=1090660 485760 0 180 $X=1087260 $Y=481315
X41683 VSS: 2 VSS: 5784 5783 5782 2 NOR2X2_HS $T=1093880 485760 0 180 $X=1090480 $Y=481315
X41692 VSS: 2 VSS: 5785 5628 5786 2 NOR2X2_HS $T=1086980 485760 0 0 $X=1086800 $Y=485495
X41709 VSS: 2 VSS: 5781 5787 5619 5620 3859 2 AOI22X1_HS $T=1086980 494040 0 0 $X=1086800 $Y=493775
X41718 VSS: 2 VSS: 5715 3491 2 BUFX4_HS $T=1082840 502320 1 0 $X=1082660 $Y=497875
X41737 VSS: 2 VSS: 5908 8032 4466 5098 2 DFFX1_HS $T=1090660 510600 1 0 $X=1090480 $Y=506155
X41743 VSS: 2 VSS: 5626 8033 4466 5053 2 DFFX1_HS $T=1086060 510600 0 0 $X=1085880 $Y=510335
X41758 VSS: 2 VSS: 5788 7229 2945 4967 2 DFFX4_HS $T=1096180 518880 0 0 $X=1096000 $Y=518615
X41763 VSS: 2 VSS: 5636 5789 2312 2311 5788 2 AOI22X1 $T=1086520 527160 0 180 $X=1083580 $Y=522715
X41775 VSS: 2 VSS: 5789 7230 2945 4968 2 DFFX4_HS $T=1090660 527160 0 0 $X=1090480 $Y=526895
X41782 VSS: 2 VSS: 5641 7231 2945 5053 2 DFFX4_HS $T=1090660 535440 1 0 $X=1090480 $Y=530995
X41789 VSS: 2 VSS: 5538 4795 2 BUFX16_HS $T=1094800 535440 0 0 $X=1094620 $Y=535175
X41799 VSS: 2 VSS: 5792 7232 2945 4884 2 DFFX4_HS $T=1093420 543720 1 0 $X=1093240 $Y=539275
X41805 VSS: 2 VSS: 5790 4302 2785 2796 5467 2 AOI22X1 $T=1089280 543720 0 0 $X=1089100 $Y=543455
X41813 VSS: 2 VSS: 5787 4216 2 BUFX16_HS $T=1085140 552000 1 0 $X=1084960 $Y=547555
X41827 VSS: 2 VSS: 5643 4657 5641 5788 4795 2 AOI22X1_HS $T=1090200 560280 0 180 $X=1086800 $Y=555835
X41838 VSS: 2 VSS: 5791 5788 3620 5016 5641 2 AOI22X2_HS $T=1094800 560280 1 180 $X=1089100 $Y=560015
X41846 VSS: 2 VSS: 5793 4127 5792 5789 4575 2 AOI22X2_HS $T=1100320 568560 0 180 $X=1094620 $Y=564115
X41880 VSS: 2 VSS: 5932 5468 3540 4705 5649 2 AOI22X2_HS $T=1097100 585120 1 0 $X=1096920 $Y=580675
X41886 VSS: 2 VSS: 5663 5645 5796 2 NAND2X4_HS $T=1085140 585120 0 0 $X=1084960 $Y=584855
X41896 VSS: 2 VSS: 5650 5797 5648 2 AND2X1_HS $T=1088360 593400 1 0 $X=1088180 $Y=588955
X41925 VSS: 2 VSS: 5656 5651 5799 4477 5798 2 NAND4X1 $T=1083760 609960 1 0 $X=1083580 $Y=605515
X41939 VSS: 2 VSS: 5798 5800 1701 1726 5792 2 AOI22X1 $T=1095720 609960 0 0 $X=1095540 $Y=609695
X41943 VSS: 2 VSS: 5657 5795 2 INVX2_HS $T=1084220 618240 0 180 $X=1081740 $Y=613795
X41949 VSS: 2 VSS: 5800 7233 2945 4812 2 DFFX4_HS $T=1096640 618240 1 0 $X=1096460 $Y=613795
X41998 VSS: 2 VSS: 5801 5800 5664 2 NAND2X4_HS $T=1098480 643080 0 180 $X=1093240 $Y=638635
X42015 VSS: 2 VSS: 5802 5670 5313 2 NAND2X1 $T=1104460 13800 0 0 $X=1104280 $Y=13535
X42019 VSS: 2 VSS: 5803 5314 5802 2 AND2X2_HS $T=1102620 22080 0 180 $X=1099220 $Y=17635
X42024 VSS: 2 VSS: 2612 5945 2 BUFX16_HS $T=1122860 22080 0 180 $X=1112560 $Y=17635
X42028 VSS: 2 VSS: 5804 5803 5805 2 NAND2X4_HS $T=1104460 22080 0 0 $X=1104280 $Y=21815
X42037 VSS: 2 VSS: 5805 5362 5673 2 AND2X1_HS $T=1102160 30360 0 0 $X=1101980 $Y=30095
X42045 VSS: 2 VSS: 5806 5361 3022 3205 5674 2 AOI22X1 $T=1108140 38640 1 0 $X=1107960 $Y=34195
X42066 VSS: 2 VSS: 5807 5365 3022 3205 5952 2 AOI22X1 $T=1115500 55200 0 180 $X=1112560 $Y=50755
X42075 VSS: 2 VSS: 5949 7234 4461 5484 2 DFFX4_HS $T=1112280 63480 1 0 $X=1112100 $Y=59035
X42078 VSS: 2 VSS: 5808 8034 4463 5486 2 DFFX1_HS $T=1104000 63480 0 0 $X=1103820 $Y=63215
X42082 VSS: 2 VSS: 5809 7235 4461 5486 2 DFFX4_HS $T=1100780 71760 1 0 $X=1100600 $Y=67315
X42086 VSS: 2 VSS: 5954 7236 4396 5486 2 DFFX4_HS $T=1110900 71760 0 0 $X=1110720 $Y=71495
X42094 VSS: 2 VSS: 5952 8035 4463 5810 2 DFFX1_HS $T=1109980 80040 0 0 $X=1109800 $Y=79775
X42096 VSS: 2 VSS: 5811 7237 4331 5486 2 DFFX4_HS $T=1099400 88320 1 0 $X=1099220 $Y=83875
X42098 VSS: 2 VSS: 5956 7238 4530 5486 2 DFFX4_HS $T=1112740 88320 1 0 $X=1112560 $Y=83875
X42101 VSS: 2 VSS: 5810 5675 2 CLKBUFX8 $T=1104920 88320 0 0 $X=1104740 $Y=88055
X42104 VSS: 2 VSS: 5957 5325 3028 3029 5953 2 AOI22X1 $T=1116880 88320 1 180 $X=1113940 $Y=88055
X42111 VSS: 2 VSS: 5284 5686 5812 2 NAND2X2_HS $T=1099860 96600 0 0 $X=1099680 $Y=96335
X42112 VSS: 2 VSS: 5675 5778 2 CLKBUFX2 $T=1103080 96600 0 0 $X=1102900 $Y=96335
X42115 VSS: 2 VSS: 5958 7239 4396 5810 2 DFFX4_HS $T=1110900 96600 0 0 $X=1110720 $Y=96335
X42120 VSS: 2 VSS: 5960 7240 4530 5810 2 DFFX4_HS $T=1111360 104880 1 0 $X=1111180 $Y=100435
X42128 VSS: 2 VSS: 5813 3867 2 CLKBUFX4 $T=1103080 113160 1 0 $X=1102900 $Y=108715
X42132 VSS: 2 VSS: 5961 7241 4530 5202 2 DFFX4_HS $T=1109060 113160 1 0 $X=1108880 $Y=108715
X42135 VSS: 2 VSS: 5814 4781 2 BUFX8 $T=1100320 113160 0 0 $X=1100140 $Y=112895
X42140 VSS: 2 VSS: 5693 3461 5695 5690 4179 2 AOI22X2_HS $T=1098480 121440 1 0 $X=1098300 $Y=116995
X42151 VSS: 2 VSS: 5968 7242 4530 5484 2 DFFX4_HS $T=1106300 129720 1 0 $X=1106120 $Y=125275
X42166 VSS: 2 VSS: 5815 5089 2 CLKBUFX2 $T=1104000 146280 1 0 $X=1103820 $Y=141835
X42171 VSS: 2 VSS: 5962 5815 2 CLKBUFX4 $T=1113200 146280 1 0 $X=1113020 $Y=141835
X42176 VSS: 2 VSS: 2102 5816 2 BUFX16_HS $T=1110440 146280 0 0 $X=1110260 $Y=146015
X42184 VSS: 2 VSS: 5817 4426 2 BUFX4_HS $T=1104000 154560 0 0 $X=1103820 $Y=154295
X42193 VSS: 2 VSS: 5291 5819 5818 2 NAND2X2_HS $T=1109520 162840 1 0 $X=1109340 $Y=158395
X42197 VSS: 2 VSS: 5819 5493 5820 2 NOR2X4_HS $T=1106300 162840 0 0 $X=1106120 $Y=162575
X42201 VSS: 2 VSS: 5703 3461 5701 5702 5821 2 AOI22X2_HS $T=1101240 171120 1 0 $X=1101060 $Y=166675
X42207 VSS: 2 VSS: 5822 4429 2 CLKBUFX2 $T=1101700 171120 0 0 $X=1101520 $Y=170855
X42208 VSS: 2 VSS: 5702 8036 4331 5366 2 DFFX1_HS $T=1104000 171120 0 0 $X=1103820 $Y=170855
X42215 VSS: 2 VSS: 5981 8037 4331 5810 2 DFFX1_HS $T=1113200 179400 1 0 $X=1113020 $Y=174955
X42222 VSS: 2 VSS: 5983 7243 4920 5366 2 DFFX4_HS $T=1109980 187680 1 0 $X=1109800 $Y=183235
X42228 VSS: 2 VSS: 5985 7244 4920 5322 2 DFFX4_HS $T=1114120 187680 0 0 $X=1113940 $Y=187415
X42230 VSS: 2 VSS: 4087 5823 2 CLKBUFX8 $T=1105840 195960 0 180 $X=1100600 $Y=191515
X42238 VSS: 2 VSS: 5322 5825 2 CLKBUFX8 $T=1105380 204240 0 180 $X=1100140 $Y=199795
X42250 VSS: 2 VSS: 5830 5829 5824 5828 5827 2 NAND4X1 $T=1110900 212520 0 180 $X=1107960 $Y=208075
X42254 VSS: 2 VSS: 5711 5832 5831 2 NOR2X2_HS $T=1104000 212520 0 0 $X=1103820 $Y=212255
X42260 VSS: 2 VSS: 5833 5705 2320 2558 5528 2 AOI22X1 $T=1104460 220800 1 0 $X=1104280 $Y=216355
X42265 VSS: 2 VSS: 5825 5835 2 CLKBUFX4 $T=1101700 220800 0 0 $X=1101520 $Y=220535
X42267 VSS: 2 VSS: 5835 5384 2 CLKBUFX2 $T=1106300 220800 0 0 $X=1106120 $Y=220535
X42268 VSS: 2 VSS: 5837 5834 5836 5830 2 NOR3X1 $T=1110900 220800 1 180 $X=1108420 $Y=220535
X42272 VSS: 2 VSS: 5834 5839 5518 5838 5833 2 NAND4X1 $T=1106300 229080 0 180 $X=1103360 $Y=224635
X42280 VSS: 2 VSS: 5841 5727 5840 5813 5814 2 AOI22X1_HS $T=1112280 229080 1 180 $X=1108880 $Y=228815
X42284 VSS: 2 VSS: 5829 5387 1695 1716 5727 2 AOI22X1 $T=1106300 237360 0 180 $X=1103360 $Y=232915
X42290 VSS: 2 VSS: 5826 8038 4964 5368 2 DFFX1_HS $T=1107220 237360 0 0 $X=1107040 $Y=237095
X42291 VSS: 2 VSS: rdata_o[10] 5842 5837 5717 5542 2 NAND4X1 $T=1098020 245640 1 0 $X=1097840 $Y=241195
X42299 VSS: 2 VSS: 5832 5844 5841 5545 2 NAND3X2_HS $T=1107680 245640 1 180 $X=1102900 $Y=245375
X42301 VSS: 2 VSS: 5368 4924 2 CLKBUFX8 $T=1108600 245640 0 0 $X=1108420 $Y=245375
X42306 VSS: 2 VSS: 5842 5845 2785 2796 5419 2 AOI22X1 $T=1103540 253920 1 0 $X=1103360 $Y=249475
X42312 VSS: 2 VSS: 5367 5847 2 CLKBUFX4 $T=1104460 253920 1 180 $X=1101520 $Y=253655
X42314 VSS: 2 VSS: 5848 5846 5840 5727 5787 2 AOI22X1_HS $T=1109520 253920 1 180 $X=1106120 $Y=253655
X42322 VSS: 2 VSS: 5851 5850 5544 5848 5849 2 NAND4X2_HS $T=1114580 262200 0 180 $X=1108880 $Y=257755
X42326 VSS: 2 VSS: 5546 5851 5852 2 NOR2X2_HS $T=1106760 262200 0 0 $X=1106580 $Y=261935
X42332 VSS: 2 VSS: 5844 5854 5853 2 AND2X1_HS $T=1110440 270480 0 180 $X=1107500 $Y=266035
X42339 VSS: 2 VSS: 5854 4986 5856 5826 5817 2 AOI22X2_HS $T=1110440 270480 0 0 $X=1110260 $Y=270215
X42342 VSS: 2 VSS: 5849 5857 5856 5826 5855 2 AOI22X2_HS $T=1107680 278760 1 0 $X=1107500 $Y=274315
X42344 VSS: 2 VSS: 5564 8039 1824 5714 2 DFFX1_HS $T=1098020 278760 0 0 $X=1097840 $Y=278495
X42351 VSS: 2 VSS: 5549 5282 5858 5859 5038 2 AOI22X2_HS $T=1114120 287040 0 180 $X=1108420 $Y=282595
X42353 VSS: 2 VSS: 5860 4732 2 CLKBUFX8 $T=1100320 287040 0 0 $X=1100140 $Y=286775
X42362 VSS: 2 VSS: rdata_o[1] 5861 5863 5725 5406 2 NAND4X1 $T=1099400 295320 0 0 $X=1099220 $Y=295055
X42365 VSS: 2 VSS: 5862 5209 2 CLKBUFX8 $T=1104920 295320 0 0 $X=1104740 $Y=295055
X42370 VSS: 2 VSS: 5865 4223 5720 5721 4094 2 AOI22X2 $T=1104000 303600 1 0 $X=1103820 $Y=299155
X42381 VSS: 2 VSS: 5730 4986 5866 5867 4987 2 AOI22X2_HS $T=1109980 311880 1 0 $X=1109800 $Y=307435
X42385 VSS: 2 VSS: 5868 5855 5867 5866 5857 2 AOI22X2_HS $T=1103080 311880 0 0 $X=1102900 $Y=311615
X42386 VSS: 2 VSS: 5729 5869 5870 4914 5255 2 AOI22X1_HS $T=1111820 311880 1 180 $X=1108420 $Y=311615
X42391 VSS: 2 VSS: 5823 5871 2 CLKBUFX4 $T=1109980 320160 0 180 $X=1107040 $Y=315715
X42397 VSS: 2 VSS: 5731 960 5870 5869 4929 2 AOI22X2_HS $T=1107220 320160 0 0 $X=1107040 $Y=319895
X42400 VSS: 2 VSS: 5873 5868 5872 5732 2 NAND3X2_HS $T=1099860 328440 1 0 $X=1099680 $Y=323995
X42405 VSS: 2 VSS: 5872 5874 5571 5570 5787 2 AOI22X1 $T=1102620 328440 1 180 $X=1099680 $Y=328175
X42411 VSS: 2 VSS: 5875 5415 1695 1716 5570 2 AOI22X1 $T=1099860 336720 1 0 $X=1099680 $Y=332275
X42415 VSS: 2 VSS: 5871 6007 5560 5883 2 ICGPRECX1 $T=1122400 336720 0 180 $X=1113480 $Y=332275
X42419 VSS: 2 VSS: 5726 5877 5415 5414 5876 2 AOI22X2_HS $T=1109060 336720 1 180 $X=1103360 $Y=336455
X42423 VSS: 2 VSS: 5878 3305 5736 2 NOR2X2 $T=1101700 345000 0 180 $X=1098760 $Y=340555
X42433 VSS: 2 VSS: 5712 5879 2 CLKBUFX2 $T=1100320 353280 0 180 $X=1097840 $Y=348835
X42434 VSS: 2 VSS: 5880 5738 3149 2 NOR2X1 $T=1100320 353280 1 0 $X=1100140 $Y=348835
X42436 VSS: 2 VSS: 5879 5737 5574 5742 2 ICGPRECX1 $T=1112740 353280 0 180 $X=1103820 $Y=348835
X42437 VSS: 2 VSS: 6006 5593 5422 5881 2 OAI21X2_HS $T=1112740 353280 1 0 $X=1112560 $Y=348835
X42440 VSS: 2 VSS: 5421 5880 2287 2 NAND2X4 $T=1104920 353280 1 180 $X=1100600 $Y=353015
X42444 VSS: 2 VSS: 5882 5593 5422 5421 2 OAI21X1_HS $T=1102160 361560 0 180 $X=1099220 $Y=357115
X42448 VSS: 2 VSS: 5883 5423 5422 5881 2 OAI21X2_HS $T=1109980 361560 1 0 $X=1109800 $Y=357115
X42450 VSS: 2 VSS: 5741 5740 5422 5421 2 OAI21X1_HS $T=1101700 361560 1 180 $X=1098760 $Y=361295
X42459 VSS: 2 VSS: 5744 5878 2287 2 NAND2X4_HS $T=1109520 369840 1 0 $X=1109340 $Y=365395
X42465 VSS: 2 VSS: 5885 5740 5422 5884 2 OAI21X1_HS $T=1112280 369840 0 0 $X=1112100 $Y=369575
X42468 VSS: 2 VSS: 5886 2 TIELO $T=1104460 378120 0 180 $X=1102900 $Y=373675
X42472 VSS: 2 VSS: 5887 5593 5422 5744 2 OAI21X1_HS $T=1099860 378120 0 0 $X=1099680 $Y=377855
X42474 VSS: 2 VSS: 5745 5886 5574 5887 2 ICGPRECX1 $T=1112280 378120 1 180 $X=1103360 $Y=377855
X42477 VSS: 2 VSS: 5749 2 TIELO $T=1101240 386400 1 0 $X=1101060 $Y=381955
X42481 VSS: 2 VSS: 5889 5442 5422 5888 2 OAI21X1_HS $T=1111820 386400 1 0 $X=1111640 $Y=381955
X42482 VSS: 2 VSS: 5890 2 TIELO $T=1101700 386400 1 180 $X=1100140 $Y=386135
X42490 VSS: 2 VSS: 5891 5442 5422 5744 2 OAI21X1_HS $T=1106760 394680 0 180 $X=1103820 $Y=390235
X42493 VSS: 2 VSS: 5894 5890 5574 5891 2 ICGPRECX1 $T=1109060 394680 1 0 $X=1108880 $Y=390235
X42494 VSS: 2 VSS: 5753 5442 5422 5892 2 OAI21X1_HS $T=1108600 394680 1 180 $X=1105660 $Y=394415
X42499 VSS: 2 VSS: 5893 2 TIELO $T=1109060 402960 0 180 $X=1107500 $Y=398515
X42500 VSS: 2 VSS: 4217 5894 2 CLKBUFX8 $T=1114120 402960 0 180 $X=1108880 $Y=398515
X42504 VSS: 2 VSS: 5892 5880 2287 2 NAND2X2_HS $T=1102160 402960 0 0 $X=1101980 $Y=402695
X42507 VSS: 2 VSS: 5895 5740 5422 5888 2 OAI21X1_HS $T=1115500 402960 1 180 $X=1112560 $Y=402695
X42511 VSS: 2 VSS: 5897 6020 5574 6019 2 ICGPRECX1 $T=1118260 411240 0 180 $X=1109340 $Y=406795
X42513 VSS: 2 VSS: 5757 5747 5422 5892 2 OAI21X1_HS $T=1101700 411240 1 180 $X=1098760 $Y=410975
X42518 VSS: 2 VSS: 5773 5900 5430 5898 2 ICGPRECX1 $T=1106760 419520 0 180 $X=1097840 $Y=415075
X42522 VSS: 2 VSS: 5899 6028 5577 5901 2 ICGPRECX1 $T=1118720 419520 0 180 $X=1109800 $Y=415075
X42526 VSS: 2 VSS: 5900 2 TIELO $T=1107680 419520 1 180 $X=1106120 $Y=419255
X42531 VSS: 2 VSS: 5778 5899 2 CLKBUFX8 $T=1109060 427800 0 180 $X=1103820 $Y=423355
X42534 VSS: 2 VSS: 5603 5752 5422 5892 2 OAI21X1_HS $T=1098020 427800 0 0 $X=1097840 $Y=427535
X42539 VSS: 2 VSS: 5901 5443 5422 5888 2 OAI21X1_HS $T=1115040 427800 1 180 $X=1112100 $Y=427535
X42542 VSS: 2 VSS: 5902 5747 5422 5888 2 OAI21X2_HS $T=1109520 436080 1 0 $X=1109340 $Y=431635
X42545 VSS: 2 VSS: 5903 2 TIELO $T=1100780 436080 1 180 $X=1099220 $Y=435815
X42548 VSS: 2 VSS: 5906 4511 2 BUFX8 $T=1102160 436080 0 0 $X=1101980 $Y=435815
X42549 VSS: 2 VSS: 5768 5285 5904 5905 3453 2 AOI22X2_HS $T=1112740 436080 1 180 $X=1107040 $Y=435815
X42554 VSS: 2 VSS: 5907 5897 2 CLKBUFX4 $T=1111360 444360 0 180 $X=1108420 $Y=439915
X42557 VSS: 2 VSS: 5765 5906 5908 5909 5145 2 AOI22X2_HS $T=1104000 444360 1 180 $X=1098300 $Y=444095
X42567 VSS: 2 VSS: 5910 5209 2 CLKBUFX4 $T=1103540 452640 0 0 $X=1103360 $Y=452375
X42568 VSS: 2 VSS: 5776 8040 4466 5910 2 DFFX1_HS $T=1106300 452640 0 0 $X=1106120 $Y=452375
X42571 VSS: 2 VSS: 5771 5282 5457 5911 5038 2 AOI22X1 $T=1104920 460920 1 0 $X=1104740 $Y=456475
X42574 VSS: 2 VSS: 5777 5774 5913 2 AND2X1_HS $T=1100780 460920 1 180 $X=1097840 $Y=460655
X42579 VSS: 2 VSS: 6042 5912 2013 2012 5776 2 AOI22X1 $T=1112740 460920 0 0 $X=1112560 $Y=460655
X42586 VSS: 2 VSS: 5913 4986 5912 6043 4987 2 AOI22X2_HS $T=1119180 469200 0 180 $X=1113480 $Y=464755
X42593 VSS: 2 VSS: 5780 4296 5912 6043 6044 2 AOI22X2 $T=1118720 469200 1 180 $X=1113940 $Y=468935
X42601 VSS: 2 VSS: 5916 3785 5904 5905 4258 2 AOI22X1_HS $T=1103540 477480 0 0 $X=1103360 $Y=477215
X42602 VSS: 2 VSS: 5914 5915 2 CLKBUFX8 $T=1106760 477480 0 0 $X=1106580 $Y=477215
X42604 VSS: 2 VSS: 5915 5623 2 CLKBUFX2 $T=1113660 477480 0 0 $X=1113480 $Y=477215
X42606 VSS: 2 VSS: 5783 5918 5916 5920 5919 2 NAND4X1_HS $T=1104920 485760 1 0 $X=1104740 $Y=481315
X42607 VSS: 2 VSS: rdata_o[2] 5625 5922 5921 5621 2 NAND4X1 $T=1108140 485760 1 0 $X=1107960 $Y=481315
X42612 VSS: 2 VSS: 5919 4839 5457 5911 3580 2 AOI22X1_HS $T=1104460 485760 0 0 $X=1104280 $Y=485495
X42619 VSS: 2 VSS: 5911 8041 4466 5923 2 DFFX1_HS $T=1109980 494040 1 0 $X=1109800 $Y=489595
X42621 VSS: 2 VSS: 5924 5911 2317 2343 5775 2 AOI22X1 $T=1105840 494040 1 180 $X=1102900 $Y=493775
X42625 VSS: 2 VSS: 5923 5090 2 CLKBUFX8 $T=1109060 494040 0 0 $X=1108880 $Y=493775
X42628 VSS: 2 VSS: 5920 4094 5909 5908 4223 2 AOI22X1_HS $T=1103540 502320 0 180 $X=1100140 $Y=497875
X42634 VSS: 2 VSS: 5921 5908 2991 2992 5626 2 AOI22X1 $T=1103080 502320 0 0 $X=1102900 $Y=502055
X42639 VSS: 2 VSS: 6049 4128 2 CLKBUFX8 $T=1112740 502320 0 0 $X=1112560 $Y=502055
X42640 VSS: 2 VSS: 5925 5259 2 CLKBUFX8 $T=1104920 510600 0 180 $X=1099680 $Y=506155
X42641 VSS: 2 VSS: 5904 8042 4466 5925 2 DFFX1_HS $T=1104920 510600 1 0 $X=1104740 $Y=506155
X42646 VSS: 2 VSS: 5926 5909 3039 3198 5904 2 AOI22X1 $T=1108140 510600 1 180 $X=1105200 $Y=510335
X42648 VSS: 2 VSS: 5463 5907 2 CLKBUFX2 $T=1108600 510600 0 0 $X=1108420 $Y=510335
X42652 VSS: 2 VSS: 5927 5338 1695 1716 5619 2 AOI22X1 $T=1101700 518880 1 0 $X=1101520 $Y=514435
X42660 VSS: 2 VSS: 5465 8043 4466 4884 2 DFFX1_HS $T=1102620 527160 1 0 $X=1102440 $Y=522715
X42679 VSS: 2 VSS: 5912 8044 4466 4893 2 DFFX1_HS $T=1102620 543720 0 0 $X=1102440 $Y=543455
X42684 VSS: 2 VSS: 5928 4309 2991 2992 5929 2 AOI22X1 $T=1109520 552000 0 180 $X=1106580 $Y=547555
X42688 VSS: 2 VSS: 5931 7245 2945 5930 2 DFFX4_HS $T=1101700 552000 0 0 $X=1101520 $Y=551735
X42691 VSS: 2 VSS: 5775 8045 4466 4759 2 DFFX1_HS $T=1101700 560280 1 0 $X=1101520 $Y=555835
X42694 VSS: 2 VSS: 6059 7246 4880 4759 2 DFFX4_HS $T=1113200 560280 1 0 $X=1113020 $Y=555835
X42706 VSS: 2 VSS: 5797 4840 5789 5792 4729 2 AOI22X1 $T=1099860 568560 0 0 $X=1099680 $Y=568295
X42711 VSS: 2 VSS: 5933 5793 5932 2 NAND2X2_HS $T=1098020 576840 1 0 $X=1097840 $Y=572395
X42716 VSS: 2 VSS: 6064 7247 4883 4759 2 DFFX4_HS $T=1111360 576840 1 0 $X=1111180 $Y=572395
X42718 VSS: 2 VSS: 5795 5791 5646 2 NAND2X2_HS $T=1098940 576840 0 0 $X=1098760 $Y=576575
X42732 VSS: 2 VSS: 6068 7248 3904 4759 2 DFFX4_HS $T=1111820 585120 0 0 $X=1111640 $Y=584855
X42735 VSS: 2 VSS: 5796 5933 2 INVX2_HS $T=1101240 593400 1 0 $X=1101060 $Y=588955
X42742 VSS: 2 VSS: 6070 7249 3904 4886 2 DFFX4_HS $T=1109060 593400 0 0 $X=1108880 $Y=593135
X42744 VSS: 2 VSS: 5652 5934 2320 2558 5649 2 AOI22X1 $T=1098940 601680 1 0 $X=1098760 $Y=597235
X42750 VSS: 2 VSS: 5934 7250 2945 4886 2 DFFX4_HS $T=1098480 601680 0 0 $X=1098300 $Y=601415
X42756 VSS: 2 VSS: 5937 5333 5936 5934 4796 2 AOI22X2_HS $T=1109520 609960 1 0 $X=1109340 $Y=605515
X42761 VSS: 2 VSS: 5938 5935 5937 2 AND2X2_HS $T=1113200 609960 1 180 $X=1109800 $Y=609695
X42770 VSS: 2 VSS: 5940 1683 5934 5936 5939 2 AOI22X2_HS $T=1116880 618240 1 180 $X=1111180 $Y=617975
X42772 VSS: 2 VSS: 5660 5931 3028 3029 4190 2 AOI22X1 $T=1099400 626520 1 0 $X=1099220 $Y=622075
X42782 VSS: 2 VSS: 6074 2596 5794 5931 2595 2 AOI22X2_HS $T=1114120 626520 0 0 $X=1113940 $Y=626255
X42786 VSS: 2 VSS: 5662 5940 6074 5941 5801 2 NAND4X4_HS $T=1118260 634800 0 180 $X=1109340 $Y=630355
X42790 VSS: 2 VSS: 5661 5938 5942 2 NAND2X4_HS $T=1112740 634800 1 180 $X=1107500 $Y=634535
X42801 VSS: 2 VSS: 5944 4046 5943 5674 3186 2 AOI22X2_HS $T=1132520 13800 0 180 $X=1126820 $Y=9355
X42821 VSS: 2 VSS: 6079 5804 6080 2 NOR2X2_HS $T=1129760 22080 0 0 $X=1129580 $Y=21815
X42822 VSS: 2 VSS: 5943 7251 4461 5202 2 DFFX4_HS $T=1114580 30360 1 0 $X=1114400 $Y=25915
X42829 VSS: 2 VSS: 5947 8046 4463 5202 2 DFFX1_HS $T=1116420 30360 0 0 $X=1116240 $Y=30095
X42840 VSS: 2 VSS: 5946 5316 3028 3029 5949 2 AOI22X1 $T=1119180 38640 1 180 $X=1116240 $Y=38375
X42849 VSS: 2 VSS: 6086 4877 5949 5948 5285 2 AOI22X2 $T=1128840 46920 1 0 $X=1128660 $Y=42475
X42854 VSS: 2 VSS: 5950 5309 3028 3029 5951 2 AOI22X1 $T=1117800 46920 1 180 $X=1114860 $Y=46655
X42868 VSS: 2 VSS: 5951 8047 4463 5484 2 DFFX1_HS $T=1116420 55200 0 0 $X=1116240 $Y=54935
X42880 VSS: 2 VSS: 5953 7252 4396 5484 2 DFFX4_HS $T=1115040 71760 1 0 $X=1114860 $Y=67315
X42889 VSS: 2 VSS: 5955 7253 4396 5202 2 DFFX4_HS $T=1114580 80040 1 0 $X=1114400 $Y=75595
X42900 VSS: 2 VSS: 5812 6102 6096 2 NOR2X2_HS $T=1129760 80040 0 0 $X=1129580 $Y=79775
X42912 VSS: 2 VSS: 5959 5490 3022 3205 5958 2 AOI22X1 $T=1118260 96600 0 180 $X=1115320 $Y=92155
X42917 VSS: 2 VSS: 1229 6103 2 BUFX16_HS $T=1138040 96600 0 180 $X=1127740 $Y=92155
X42924 VSS: 2 VSS: 6088 8048 4463 5925 2 DFFX1_HS $T=1125620 96600 0 0 $X=1125440 $Y=96335
X42928 VSS: 2 VSS: 6091 7254 4396 5925 2 DFFX4_HS $T=1128840 104880 1 0 $X=1128660 $Y=100435
X42932 VSS: 2 VSS: 5202 5962 2 CLKBUFX4 $T=1120100 104880 1 180 $X=1117160 $Y=104615
X42934 VSS: 2 VSS: 5963 5960 5961 5208 5003 2 AOI22X1_HS $T=1120560 104880 0 0 $X=1120380 $Y=104615
X42939 VSS: 2 VSS: 5965 5964 5963 2 AND2X1_HS $T=1127920 113160 1 0 $X=1127740 $Y=108715
X42945 VSS: 2 VSS: 5966 3186 5960 5961 4046 2 AOI22X2 $T=1119180 113160 0 0 $X=1119000 $Y=112895
X42956 VSS: 2 VSS: 5967 5494 3022 3205 5960 2 AOI22X1 $T=1117800 121440 1 180 $X=1114860 $Y=121175
X42970 VSS: 2 VSS: 5969 5327 3028 3029 5968 2 AOI22X1 $T=1117800 129720 1 180 $X=1114860 $Y=129455
X42979 VSS: 2 VSS: 5972 5965 5970 5971 2 NAND3X2_HS $T=1129760 138000 0 180 $X=1124980 $Y=133555
X42985 VSS: 2 VSS: 5974 5692 5973 2 NOR2X2_HS $T=1115960 138000 0 0 $X=1115780 $Y=137735
X42990 VSS: 2 VSS: 5816 5975 5974 2 NAND2X2_HS $T=1119180 146280 0 180 $X=1115780 $Y=141835
X43001 VSS: 2 VSS: 5977 5334 3028 3029 5976 2 AOI22X1 $T=1117340 154560 0 180 $X=1114400 $Y=150115
X43009 VSS: 2 VSS: 5976 8049 4331 5484 2 DFFX1_HS $T=1114580 154560 0 0 $X=1114400 $Y=154295
X43016 VSS: 2 VSS: 5818 5979 5978 2 NOR2X2_HS $T=1125160 162840 1 0 $X=1124980 $Y=158395
X43036 VSS: 2 VSS: 5980 4834 2 INVX8_HS $T=1121020 171120 0 0 $X=1120840 $Y=170855
X43046 VSS: 2 VSS: 5982 5485 3022 3205 5981 2 AOI22X1 $T=1120560 179400 1 180 $X=1117620 $Y=179135
X43055 VSS: 2 VSS: 5989 8050 4964 5484 2 DFFX1_HS $T=1128380 187680 1 0 $X=1128200 $Y=183235
X43060 VSS: 2 VSS: 5984 5255 2 BUFX8_HS $T=1126540 187680 0 0 $X=1126360 $Y=187415
X43065 VSS: 2 VSS: 6129 7255 4920 5279 2 DFFX4_HS $T=1123780 195960 1 0 $X=1123600 $Y=191515
X43072 VSS: 2 VSS: 6130 7256 4920 5283 2 DFFX4_HS $T=1123780 195960 0 0 $X=1123600 $Y=195695
X43078 VSS: 2 VSS: 6131 4870 5716 5986 4946 2 AOI22X2 $T=1127000 204240 1 0 $X=1126820 $Y=199795
X43083 VSS: 2 VSS: 5279 5988 2 CLKBUFX4 $T=1115500 204240 0 0 $X=1115320 $Y=203975
X43085 VSS: 2 VSS: 5987 5379 3028 3029 5989 2 AOI22X1 $T=1122860 204240 1 180 $X=1119920 $Y=203975
X43099 VSS: 2 VSS: 5283 5990 2 CLKBUFX8 $T=1118260 212520 0 0 $X=1118080 $Y=212255
X43114 VSS: 2 VSS: 5836 5992 5987 5718 5993 2 NAND4X1 $T=1126080 220800 1 180 $X=1123140 $Y=220535
X43120 VSS: 2 VSS: 5993 5381 3022 3205 5994 2 AOI22X1 $T=1126080 229080 0 180 $X=1123140 $Y=224635
X43133 VSS: 2 VSS: 5838 5995 2555 2564 5840 2 AOI22X1 $T=1126540 237360 1 0 $X=1126360 $Y=232915
X43140 VSS: 2 VSS: 5485 7257 4331 5642 2 DFFX4_HS $T=1119180 237360 0 0 $X=1119000 $Y=237095
X43142 VSS: 2 VSS: 5381 8051 4964 5642 2 DFFX1_HS $T=1115040 245640 1 0 $X=1114860 $Y=241195
X43163 VSS: 2 VSS: 5840 8052 4964 5996 2 DFFX1_HS $T=1120100 253920 0 0 $X=1119920 $Y=253655
X43176 VSS: 2 VSS: 5850 5998 5997 4971 4617 2 AOI22X2 $T=1129760 262200 1 180 $X=1124980 $Y=261935
X43181 VSS: 2 VSS: 5853 5997 5998 4914 5984 2 AOI22X1_HS $T=1132060 270480 0 180 $X=1128660 $Y=266035
X43198 VSS: 2 VSS: 5997 8053 4964 5862 2 DFFX1_HS $T=1119180 278760 0 0 $X=1119000 $Y=278495
X43211 VSS: 2 VSS: 5999 4221 5723 5724 3785 2 AOI22X1_HS $T=1119640 287040 0 0 $X=1119460 $Y=286775
X43218 VSS: 2 VSS: 6001 6002 5999 5865 6000 2 NAND4X2_HS $T=1120100 295320 1 0 $X=1119920 $Y=290875
X43227 VSS: 2 VSS: 6002 3186 5551 5550 4790 2 AOI22X1 $T=1126080 295320 1 180 $X=1123140 $Y=295055
X43228 VSS: 2 VSS: 5996 5167 2 CLKBUFX8 $T=1126080 295320 0 0 $X=1125900 $Y=295055
X43231 VSS: 2 VSS: 5571 8054 1824 5996 2 DFFX1_HS $T=1120100 303600 1 0 $X=1119920 $Y=299155
X43238 VSS: 2 VSS: 5869 8055 1824 5862 2 DFFX1_HS $T=1119640 303600 0 0 $X=1119460 $Y=303335
X43251 VSS: 2 VSS: 6003 5866 2013 2012 5869 2 AOI22X1 $T=1126540 311880 0 0 $X=1126360 $Y=311615
X43260 VSS: 2 VSS: 5704 6004 2 CLKBUFX4 $T=1117340 320160 1 180 $X=1114400 $Y=319895
X43267 VSS: 2 VSS: 6005 2 TIELO $T=1122860 328440 1 0 $X=1122680 $Y=323995
X43271 VSS: 2 VSS: 6004 6005 5560 6006 2 ICGPRECX1 $T=1136200 328440 0 180 $X=1127280 $Y=323995
X43276 VSS: 2 VSS: 5733 6001 5873 2 NOR2X2_HS $T=1118720 328440 1 180 $X=1115320 $Y=328175
X43283 VSS: 2 VSS: 6007 2 TIELO $T=1126540 336720 0 180 $X=1124980 $Y=332275
X43295 VSS: 2 VSS: 5874 3859 2 BUFX4_HS $T=1117800 345000 1 0 $X=1117620 $Y=340555
X43304 VSS: 2 VSS: 5556 6011 6009 6010 6008 2 NAND4X4_HS $T=1121480 345000 0 0 $X=1121300 $Y=344735
X43308 VSS: 2 VSS: 5990 5756 2 CLKBUFX4 $T=1125620 353280 0 180 $X=1122680 $Y=348835
X43309 VSS: 2 VSS: 6011 4681 6013 6012 3181 2 AOI22X1_HS $T=1128840 353280 0 180 $X=1125440 $Y=348835
X43315 VSS: 2 VSS: 5881 2287 5416 2 NAND2X2_HS $T=1117800 353280 0 0 $X=1117620 $Y=353015
X43319 VSS: 2 VSS: 5699 6014 2 CLKBUFX8 $T=1119640 361560 0 180 $X=1114400 $Y=357115
X43328 VSS: 2 VSS: 6010 6016 6015 2 NAND2X4 $T=1123780 361560 0 0 $X=1123600 $Y=361295
X43335 VSS: 2 VSS: 6018 2 TIELO $T=1127000 369840 1 0 $X=1126820 $Y=365395
X43336 VSS: 2 VSS: 6151 8056 1824 6017 2 DFFX1_HS $T=1128380 369840 1 0 $X=1128200 $Y=365395
X43341 VSS: 2 VSS: 5988 4217 2 CLKBUFX2 $T=1115040 369840 0 0 $X=1114860 $Y=369575
X43345 VSS: 2 VSS: 6017 5021 2 CLKBUFX4 $T=1122400 369840 0 0 $X=1122220 $Y=369575
X43349 VSS: 2 VSS: 5884 5878 2287 2 NAND2X2_HS $T=1115960 378120 1 0 $X=1115780 $Y=373675
X43360 VSS: 2 VSS: 5896 2 TIELO $T=1120560 378120 1 180 $X=1119000 $Y=377855
X43362 VSS: 2 VSS: 6014 6018 5560 5885 2 ICGPRECX1 $T=1122400 378120 0 0 $X=1122220 $Y=377855
X43367 VSS: 2 VSS: 5857 4296 2 BUFX4_HS $T=1124240 386400 1 0 $X=1124060 $Y=381955
X43373 VSS: 2 VSS: 6019 5747 5422 5744 2 OAI21X1 $T=1115500 386400 0 0 $X=1115320 $Y=386135
X43381 VSS: 2 VSS: 6020 2 TIELO $T=1125620 394680 0 180 $X=1124060 $Y=390235
X43389 VSS: 2 VSS: 6021 5752 5422 5888 2 OAI21X2_HS $T=1117340 394680 0 0 $X=1117160 $Y=394415
X43390 VSS: 2 VSS: 6022 6023 5560 6021 2 ICGPRECX1 $T=1121940 394680 0 0 $X=1121760 $Y=394415
X43392 VSS: 2 VSS: 5433 6025 2 CLKBUFX2 $T=1118720 402960 0 180 $X=1116240 $Y=398515
X43396 VSS: 2 VSS: 6024 5443 5422 5884 2 OAI21X1_HS $T=1124700 402960 0 180 $X=1121760 $Y=398515
X43404 VSS: 2 VSS: 5888 2287 5416 2 NAND2X4_HS $T=1118260 402960 0 0 $X=1118080 $Y=402695
X43407 VSS: 2 VSS: 6025 5893 5574 6024 2 ICGPRECX1 $T=1134360 402960 1 180 $X=1125440 $Y=402695
X43413 VSS: 2 VSS: 6015 5253 2 BUFX16_HS $T=1129760 411240 1 0 $X=1129580 $Y=406795
X43420 VSS: 2 VSS: 6026 5939 2 BUFX2_HS $T=1122860 411240 0 0 $X=1122680 $Y=410975
X43424 VSS: 2 VSS: 5898 5752 5422 5884 2 OAI21X1_HS $T=1121940 419520 0 180 $X=1119000 $Y=415075
X43433 VSS: 2 VSS: 6028 2 TIELO $T=1118720 419520 1 180 $X=1117160 $Y=419255
X43437 VSS: 2 VSS: 5867 8057 1824 6029 2 DFFX1_HS $T=1125160 419520 0 0 $X=1124980 $Y=419255
X43440 VSS: 2 VSS: 5601 6022 2 CLKBUFX2 $T=1123320 427800 0 180 $X=1120840 $Y=423355
X43443 VSS: 2 VSS: 6032 4681 6030 6031 3181 2 AOI22X2_HS $T=1130220 427800 0 180 $X=1124520 $Y=423355
X43452 VSS: 2 VSS: 6033 6036 6015 2 NAND2X2 $T=1132060 427800 1 180 $X=1129580 $Y=427535
X43463 VSS: 2 VSS: 5607 6027 6032 6033 6034 2 NAND4X2_HS $T=1122400 436080 0 0 $X=1122220 $Y=435815
X43469 VSS: 2 VSS: 6035 4338 6030 6031 4096 2 AOI22X1_HS $T=1127000 444360 1 0 $X=1126820 $Y=439915
X43478 VSS: 2 VSS: 6037 6036 3843 2 NAND2X2 $T=1127000 444360 1 180 $X=1124520 $Y=444095
X43484 VSS: 2 VSS: 6038 5939 6040 6039 3840 2 AOI22X1 $T=1128840 452640 0 180 $X=1125900 $Y=448195
X43493 VSS: 2 VSS: 5786 6037 6038 6041 6035 2 NAND4X2_HS $T=1124240 452640 0 0 $X=1124060 $Y=452375
X43500 VSS: 2 VSS: 5855 3810 2 BUFX8_HS $T=1128840 460920 1 0 $X=1128660 $Y=456475
X43513 VSS: 2 VSS: 6043 8058 4466 6029 2 DFFX1_HS $T=1126080 469200 1 0 $X=1125900 $Y=464755
X43522 VSS: 2 VSS: 6044 3810 2 BUFX8_HS $T=1118260 477480 1 0 $X=1118080 $Y=473035
X43537 VSS: 2 VSS: 5918 4790 5766 5767 4045 2 AOI22X1 $T=1129760 485760 1 0 $X=1129580 $Y=481315
X43545 VSS: 2 VSS: 6166 6039 2320 2558 5336 2 AOI22X1 $T=1129760 485760 0 0 $X=1129580 $Y=485495
X43551 VSS: 2 VSS: 5922 6047 6046 6045 2 NOR3X1 $T=1130220 494040 0 180 $X=1127740 $Y=489595
X43559 VSS: 2 VSS: 6029 4924 2 CLKBUFX8 $T=1121020 494040 0 0 $X=1120840 $Y=493775
X43563 VSS: 2 VSS: 6047 5924 6048 6167 6166 2 NAND4X1 $T=1132060 494040 1 180 $X=1129120 $Y=493775
X43565 VSS: 2 VSS: 5909 8059 4466 6049 2 DFFX1_HS $T=1115500 502320 1 0 $X=1115320 $Y=497875
X43574 VSS: 2 VSS: 6050 5463 2 CLKBUFX2 $T=1123780 502320 0 0 $X=1123600 $Y=502055
X43577 VSS: 2 VSS: 6039 8060 4466 4886 2 DFFX1_HS $T=1115040 510600 1 0 $X=1114860 $Y=506155
X43584 VSS: 2 VSS: 4886 5847 2 CLKBUFX8 $T=1116420 510600 0 0 $X=1116240 $Y=510335
X43586 VSS: 2 VSS: 5847 6050 2 CLKBUFX8 $T=1123320 510600 0 0 $X=1123140 $Y=510335
X43589 VSS: 2 VSS: 6054 7258 3904 4967 2 DFFX4_HS $T=1129760 510600 0 0 $X=1129580 $Y=510335
X43594 VSS: 2 VSS: 6052 6051 4700 2 NAND2X1 $T=1127000 518880 0 180 $X=1124980 $Y=514435
X43604 VSS: 2 VSS: 6053 5633 6052 2568 2 AOI21X1 $T=1125620 518880 0 0 $X=1125440 $Y=518615
X43610 VSS: 2 VSS: 6051 6055 2312 2311 6054 2 AOI22X1 $T=1130220 527160 0 180 $X=1127280 $Y=522715
X43616 VSS: 2 VSS: 5929 7259 3904 5053 2 DFFX4_HS $T=1116880 527160 0 0 $X=1116700 $Y=526895
X43621 VSS: 2 VSS: 6055 7260 3904 4968 2 DFFX4_HS $T=1124700 535440 1 0 $X=1124520 $Y=530995
X43633 VSS: 2 VSS: 6169 7261 3904 4884 2 DFFX4_HS $T=1124700 543720 1 0 $X=1124520 $Y=539275
X43641 VSS: 2 VSS: 6056 4729 2 BUFX8_HS $T=1132980 543720 1 180 $X=1127280 $Y=543455
X43647 VSS: 2 VSS: rdata_o[30] 5790 6057 5928 6053 2 NAND4X1 $T=1127460 552000 1 0 $X=1127280 $Y=547555
X43667 VSS: 2 VSS: 6067 3620 6054 5929 6061 2 AOI22X2 $T=1127460 560280 0 0 $X=1127280 $Y=560015
X43672 VSS: 2 VSS: 6061 5016 2 BUFX2_HS $T=1126540 568560 1 0 $X=1126360 $Y=564115
X43679 VSS: 2 VSS: 6063 7262 2945 6062 2 DFFX4_HS $T=1119180 568560 0 0 $X=1119000 $Y=568295
X43684 VSS: 2 VSS: 6171 5190 6170 5467 5144 2 AOI22X2 $T=1129760 576840 1 0 $X=1129580 $Y=572395
X43689 VSS: 2 VSS: 6065 7263 4883 4886 2 DFFX4_HS $T=1120560 576840 0 0 $X=1120380 $Y=576575
X43694 VSS: 2 VSS: 6066 6060 6067 6171 6172 2 NAND4X4_HS $T=1127000 585120 1 0 $X=1126820 $Y=580675
X43704 VSS: 2 VSS: 5935 5390 5931 5794 6069 2 AOI22X2_HS $T=1121480 593400 1 0 $X=1121300 $Y=588955
X43714 VSS: 2 VSS: 5653 5794 3183 2808 6063 2 AOI22X1 $T=1124700 601680 0 180 $X=1121760 $Y=597235
X43724 VSS: 2 VSS: 5306 6066 6071 2 NOR2X4_HS $T=1124240 601680 0 0 $X=1124060 $Y=601415
X43736 VSS: 2 VSS: 6072 7264 4883 4812 2 DFFX4_HS $T=1117340 609960 0 0 $X=1117160 $Y=609695
X43740 VSS: 2 VSS: 6073 7265 3904 4812 2 DFFX4_HS $T=1117800 618240 1 0 $X=1117620 $Y=613795
X43772 VSS: 2 VSS: 5942 6075 2 INVX2_HS $T=1123320 643080 0 180 $X=1120840 $Y=638635
X43785 VSS: 2 VSS: 6077 6076 5944 2 AND2X1_HS $T=1131600 13800 0 0 $X=1131420 $Y=13535
X43793 VSS: 2 VSS: 5669 6079 6078 2 NAND2X2_HS $T=1132060 22080 1 0 $X=1131880 $Y=17635
X43811 VSS: 2 VSS: 6081 4046 5947 5952 3186 2 AOI22X1 $T=1137120 30360 0 0 $X=1136940 $Y=30095
X43819 VSS: 2 VSS: 6082 6084 6085 6081 6083 2 NAND4X2_HS $T=1135740 38640 1 0 $X=1135560 $Y=34195
X43823 VSS: 2 VSS: 6076 4221 5949 5948 4047 2 AOI22X1_HS $T=1132520 38640 0 0 $X=1132340 $Y=38375
X43837 VSS: 2 VSS: 6087 6088 5951 4877 5285 2 AOI22X1_HS $T=1138040 46920 1 180 $X=1134640 $Y=46655
X43846 VSS: 2 VSS: 6084 4221 5951 6088 4047 2 AOI22X1 $T=1133440 55200 1 0 $X=1133260 $Y=50755
X43853 VSS: 2 VSS: 6090 6089 3039 3198 6088 2 AOI22X1 $T=1142180 55200 0 0 $X=1142000 $Y=54935
X43861 VSS: 2 VSS: 6092 6091 5953 4877 5285 2 AOI22X1_HS $T=1138960 63480 0 180 $X=1135560 $Y=59035
X43866 VSS: 2 VSS: 6096 6094 6095 6092 6093 2 NAND4X2_HS $T=1133440 63480 0 0 $X=1133260 $Y=63215
X43876 VSS: 2 VSS: 6097 4047 6091 5953 4221 2 AOI22X2_HS $T=1139880 71760 1 0 $X=1139700 $Y=67315
X43880 VSS: 2 VSS: 6098 4046 5955 5958 3186 2 AOI22X1_HS $T=1138960 71760 1 180 $X=1135560 $Y=71495
X43891 VSS: 2 VSS: 6099 6097 6100 6098 6101 2 NAND4X2_HS $T=1140340 80040 1 0 $X=1140160 $Y=75595
X43906 VSS: 2 VSS: 6094 5958 5955 5208 5003 2 AOI22X1 $T=1136200 88320 1 180 $X=1133260 $Y=88055
X43912 VSS: 2 VSS: 6089 8061 4463 6049 2 DFFX1_HS $T=1146780 88320 0 0 $X=1146600 $Y=88055
X43919 VSS: 2 VSS: 6105 6104 6099 2 NOR2X2_HS $T=1144480 96600 0 180 $X=1141080 $Y=92155
X43924 VSS: 2 VSS: 6103 6105 6106 2 NAND2X2_HS $T=1143560 96600 1 180 $X=1140160 $Y=96335
X43934 VSS: 2 VSS: 6106 5688 6107 2 NOR2X2_HS $T=1140340 104880 0 0 $X=1140160 $Y=104615
X43957 VSS: 2 VSS: 6111 4094 6109 6110 4205 2 AOI22X2_HS $T=1147700 121440 0 180 $X=1142000 $Y=116995
X43959 VSS: 2 VSS: 6113 6112 5966 6111 6108 2 NAND4X2_HS $T=1134360 121440 0 0 $X=1134180 $Y=121175
X43967 VSS: 2 VSS: 6112 6114 5968 4221 4047 2 AOI22X1_HS $T=1132060 129720 1 0 $X=1131880 $Y=125275
X43972 VSS: 2 VSS: 6114 7266 4530 5925 2 DFFX4_HS $T=1144940 129720 1 0 $X=1144760 $Y=125275
X43976 VSS: 2 VSS: 5970 6114 5968 4877 5285 2 AOI22X1 $T=1135740 129720 0 0 $X=1135560 $Y=129455
X43991 VSS: 2 VSS: 5975 6113 6115 2 NOR2X2_HS $T=1139880 138000 0 0 $X=1139700 $Y=137735
X43999 VSS: 2 VSS: 5698 5972 6116 2 NOR2X4_HS $T=1136200 146280 1 0 $X=1136020 $Y=141835
X44005 VSS: 2 VSS: 6117 8062 4331 5925 2 DFFX1_HS $T=1139880 146280 0 0 $X=1139700 $Y=146015
X44011 VSS: 2 VSS: 6118 6117 5976 4877 5285 2 AOI22X1_HS $T=1136660 154560 1 0 $X=1136480 $Y=150115
X44015 VSS: 2 VSS: 6119 6117 5976 4221 4047 2 AOI22X1 $T=1134820 154560 0 0 $X=1134640 $Y=154295
X44031 VSS: 2 VSS: 6121 4870 4946 6211 6120 2 AOI22X2_HS $T=1149080 162840 1 180 $X=1143380 $Y=162575
X44036 VSS: 2 VSS: 5979 6122 6118 6123 6121 2 NAND4X2_HS $T=1133440 171120 1 0 $X=1133260 $Y=166675
X44044 VSS: 2 VSS: 6123 5282 6124 5811 5038 2 AOI22X1 $T=1144940 171120 1 180 $X=1142000 $Y=170855
X44050 VSS: 2 VSS: 6122 5207 6125 5981 5003 2 AOI22X1_HS $T=1137120 179400 0 180 $X=1133720 $Y=174955
X44055 VSS: 2 VSS: 6126 5822 2 CLKBUFX8 $T=1130680 179400 0 0 $X=1130500 $Y=179135
X44056 VSS: 2 VSS: 6127 3186 5981 6125 4790 2 AOI22X1_HS $T=1135740 179400 0 0 $X=1135560 $Y=179135
X44067 VSS: 2 VSS: 5484 6126 2 CLKBUFX4 $T=1134820 187680 1 180 $X=1131880 $Y=187415
X44070 VSS: 2 VSS: 2355 6128 2 BUFX16_HS $T=1146320 187680 1 180 $X=1136020 $Y=187415
X44072 VSS: 2 VSS: 6128 6216 6219 2 NAND2X2_HS $T=1150000 187680 1 180 $X=1146600 $Y=187415
X44084 VSS: 2 VSS: 6132 8063 4964 5925 2 DFFX1_HS $T=1144940 195960 0 0 $X=1144760 $Y=195695
X44097 VSS: 2 VSS: 5828 5986 3039 3198 6132 2 AOI22X1 $T=1144020 204240 0 0 $X=1143840 $Y=203975
X44105 VSS: 2 VSS: 6133 5285 4877 5989 6132 2 AOI22X2 $T=1138960 212520 1 0 $X=1138780 $Y=208075
X44108 VSS: 2 VSS: 5831 6134 6133 5991 6131 2 NAND4X2_HS $T=1136660 212520 1 180 $X=1130960 $Y=212255
X44118 VSS: 2 VSS: 6134 5994 5995 5208 5003 2 AOI22X1 $T=1135280 220800 1 0 $X=1135100 $Y=216355
X44126 VSS: 2 VSS: 5986 8064 4964 6049 2 DFFX1_HS $T=1143100 220800 0 0 $X=1142920 $Y=220535
X44133 VSS: 2 VSS: 5994 8065 4964 5810 2 DFFX1_HS $T=1141260 229080 1 0 $X=1141080 $Y=224635
X44135 VSS: 2 VSS: 6135 4790 5995 5994 3186 2 AOI22X1_HS $T=1132520 229080 0 0 $X=1132340 $Y=228815
X44148 VSS: 2 VSS: 5995 8066 4964 6136 2 DFFX1_HS $T=1143560 237360 1 0 $X=1143380 $Y=232915
X44152 VSS: 2 VSS: 5716 8067 4964 5396 2 DFFX1_HS $T=1136660 237360 0 0 $X=1136480 $Y=237095
X44159 VSS: 2 VSS: 6137 5716 5986 4094 4223 2 AOI22X1_HS $T=1138960 245640 1 0 $X=1138780 $Y=241195
X44165 VSS: 2 VSS: 6138 3785 6132 5989 4221 2 AOI22X2_HS $T=1141260 245640 0 0 $X=1141080 $Y=245375
X44172 VSS: 2 VSS: 5852 6135 6137 6138 6139 2 NAND4X2_HS $T=1136200 253920 1 0 $X=1136020 $Y=249475
X44177 VSS: 2 VSS: 5991 5282 5845 6140 5038 2 AOI22X1 $T=1140340 253920 0 0 $X=1140160 $Y=253655
X44188 VSS: 2 VSS: 6139 3580 6140 5845 4839 2 AOI22X2_HS $T=1148160 262200 0 180 $X=1142460 $Y=257755
X44200 VSS: 2 VSS: 6225 7267 4536 5533 2 DFFX4_HS $T=1140800 270480 1 0 $X=1140620 $Y=266035
X44205 VSS: 2 VSS: 6227 7268 4504 5533 2 DFFX4_HS $T=1142180 270480 0 0 $X=1142000 $Y=270215
X44210 VSS: 2 VSS: 5992 5856 2013 2012 5997 2 AOI22X1 $T=1132520 278760 1 0 $X=1132340 $Y=274315
X44214 VSS: 2 VSS: 5723 8068 1824 6141 2 DFFX1_HS $T=1141260 278760 1 0 $X=1141080 $Y=274315
X44224 VSS: 2 VSS: 5724 8069 1824 5925 2 DFFX1_HS $T=1133440 287040 1 0 $X=1133260 $Y=282595
X44231 VSS: 2 VSS: 6000 3580 5859 5858 4839 2 AOI22X2 $T=1147240 287040 1 180 $X=1142460 $Y=286775
X44239 VSS: 2 VSS: 5551 8070 1824 5810 2 DFFX1_HS $T=1141720 295320 1 0 $X=1141540 $Y=290875
X44244 VSS: 2 VSS: 5721 8071 1824 6049 2 DFFX1_HS $T=1139880 295320 0 0 $X=1139700 $Y=295055
X44253 VSS: 2 VSS: 6142 5721 3039 3198 5724 2 AOI22X1 $T=1139880 303600 1 0 $X=1139700 $Y=299155
X44267 VSS: 2 VSS: 6143 6144 3028 3029 5723 2 AOI22X1 $T=1143560 311880 0 180 $X=1140620 $Y=307435
X44273 VSS: 2 VSS: 6145 6013 3022 3205 5551 2 AOI22X1 $T=1147700 311880 1 180 $X=1144760 $Y=311615
X44280 VSS: 2 VSS: 6146 6003 6143 5728 6145 2 NAND4X1 $T=1140340 320160 1 0 $X=1140160 $Y=315715
X44284 VSS: 2 VSS: 5863 6147 6146 6148 2 NOR3X1 $T=1134820 320160 1 180 $X=1132340 $Y=319895
X44294 VSS: 2 VSS: 6149 6016 1701 1726 5722 2 AOI22X1 $T=1140800 328440 1 0 $X=1140620 $Y=323995
X44298 VSS: 2 VSS: 6148 5875 6150 6142 6149 2 NAND4X1 $T=1138960 328440 1 180 $X=1136020 $Y=328175
X44308 VSS: 2 VSS: 6150 5867 1991 1990 6151 2 AOI22X1 $T=1137120 336720 1 0 $X=1136940 $Y=332275
X44314 VSS: 2 VSS: 6152 5980 2 INVX8_HS $T=1137580 336720 1 180 $X=1132340 $Y=336455
X44325 VSS: 2 VSS: 5930 5990 2 CLKBUFX8 $T=1132060 345000 0 0 $X=1131880 $Y=344735
X44328 VSS: 2 VSS: 6236 7269 4536 5930 2 DFFX4_HS $T=1144480 345000 0 0 $X=1144300 $Y=344735
X44334 VSS: 2 VSS: 6144 8072 1824 5930 2 DFFX1_HS $T=1139880 353280 1 0 $X=1139700 $Y=348835
X44336 VSS: 2 VSS: 6008 5390 6144 6154 6069 2 AOI22X2_HS $T=1135740 353280 0 0 $X=1135560 $Y=353015
X44343 VSS: 2 VSS: 5647 5988 2 CLKBUFX8 $T=1131140 361560 1 0 $X=1130960 $Y=357115
X44344 VSS: 2 VSS: 6009 5333 6151 6153 6152 2 AOI22X2 $T=1140800 361560 0 180 $X=1136020 $Y=357115
X44347 VSS: 2 VSS: 6062 5825 2 CLKBUFX8 $T=1144940 361560 1 0 $X=1144760 $Y=357115
X44359 VSS: 2 VSS: 6155 2595 6144 6154 2596 2 AOI22X1_HS $T=1148620 369840 0 180 $X=1145220 $Y=365395
X44364 VSS: 2 VSS: 6012 8073 1824 6062 2 DFFX1_HS $T=1142640 369840 0 0 $X=1142460 $Y=369575
X44371 VSS: 2 VSS: 6156 4338 6013 6012 4096 2 AOI22X1_HS $T=1139880 378120 1 0 $X=1139700 $Y=373675
X44376 VSS: 2 VSS: 6023 2 TIELO $T=1133440 378120 1 180 $X=1131880 $Y=377855
X44380 VSS: 2 VSS: 6157 6156 6155 2 CLKAND2X2 $T=1143560 378120 1 180 $X=1141080 $Y=377855
X44387 VSS: 2 VSS: 6016 8074 1824 5615 2 DFFX1_HS $T=1133900 386400 1 0 $X=1133720 $Y=381955
X44389 VSS: 2 VSS: 6013 8075 1824 5642 2 DFFX1_HS $T=1144940 386400 1 0 $X=1144760 $Y=381955
X44394 VSS: 2 VSS: 5735 6157 6158 6159 2 NAND3X2_HS $T=1142640 386400 0 0 $X=1142460 $Y=386135
X44401 VSS: 2 VSS: 6158 6026 6151 6153 3840 2 AOI22X1_HS $T=1138040 394680 1 0 $X=1137860 $Y=390235
X44408 VSS: 2 VSS: 6159 6016 3843 2 NAND2X1 $T=1139420 394680 1 180 $X=1137400 $Y=394415
X44411 VSS: 2 VSS: 6242 7270 4504 5925 2 DFFX4_HS $T=1144020 394680 0 0 $X=1143840 $Y=394415
X44420 VSS: 2 VSS: 6069 4749 2 BUFX16_HS $T=1144480 402960 1 0 $X=1144300 $Y=398515
X44421 VSS: 2 VSS: 6160 5255 2 BUFX4_HS $T=1134360 402960 0 0 $X=1134180 $Y=402695
X44424 VSS: 2 VSS: 4768 5253 2 BUFX16_HS $T=1150920 402960 1 180 $X=1140620 $Y=402695
X44432 VSS: 2 VSS: 6027 5333 6040 6039 6152 2 AOI22X2 $T=1140340 411240 1 180 $X=1135560 $Y=410975
X44433 VSS: 2 VSS: 5642 5691 2 CLKBUFX8 $T=1140340 411240 0 0 $X=1140160 $Y=410975
X44434 VSS: 2 VSS: 6243 8076 5258 5925 2 DFFX1_HS $T=1145400 411240 0 0 $X=1145220 $Y=410975
X44438 VSS: 2 VSS: 6040 8077 4466 6017 2 DFFX1_HS $T=1131140 419520 1 0 $X=1130960 $Y=415075
X44442 VSS: 2 VSS: 6162 8078 4466 5930 2 DFFX1_HS $T=1146320 419520 1 0 $X=1146140 $Y=415075
X44447 VSS: 2 VSS: 6030 8079 4466 5642 2 DFFX1_HS $T=1137580 419520 0 0 $X=1137400 $Y=419255
X44459 VSS: 2 VSS: 6031 8080 4466 6062 2 DFFX1_HS $T=1139880 427800 0 0 $X=1139700 $Y=427535
X44464 VSS: 2 VSS: 6034 6069 6161 6162 5390 2 AOI22X2 $T=1140800 436080 0 180 $X=1136020 $Y=431635
X44471 VSS: 2 VSS: 6048 6161 3183 2808 6031 2 AOI22X1 $T=1146320 436080 0 0 $X=1146140 $Y=435815
X44479 VSS: 2 VSS: 6250 8081 5258 5642 2 DFFX1_HS $T=1146780 444360 1 0 $X=1146600 $Y=439915
X44506 VSS: 2 VSS: 6046 6042 6163 5772 6164 2 NAND4X1 $T=1133440 460920 0 0 $X=1133260 $Y=460655
X44514 VSS: 2 VSS: 6036 8082 4466 5615 2 DFFX1_HS $T=1137120 469200 1 0 $X=1136940 $Y=464755
X44518 VSS: 2 VSS: 5905 8083 4466 6141 2 DFFX1_HS $T=1140800 469200 0 0 $X=1140620 $Y=468935
X44525 VSS: 2 VSS: 5766 8084 4466 6136 2 DFFX1_HS $T=1138960 477480 1 0 $X=1138780 $Y=473035
X44527 VSS: 2 VSS: 6165 6043 1991 1990 6040 2 AOI22X1 $T=1131140 477480 0 0 $X=1130960 $Y=477215
X44541 VSS: 2 VSS: 5767 8085 4466 5810 2 DFFX1_HS $T=1144940 485760 1 0 $X=1144760 $Y=481315
X44551 VSS: 2 VSS: 6257 7271 4883 6141 2 DFFX4_HS $T=1139420 494040 1 0 $X=1139240 $Y=489595
X44555 VSS: 2 VSS: 6258 7272 4880 4967 2 DFFX4_HS $T=1140340 494040 0 0 $X=1140160 $Y=493775
X44561 VSS: 2 VSS: 6167 5766 2555 2564 5620 2 AOI22X1 $T=1135740 502320 1 0 $X=1135560 $Y=497875
X44565 VSS: 2 VSS: 6045 5927 6165 5926 6168 2 NAND4X1 $T=1130680 502320 0 0 $X=1130500 $Y=502055
X44571 VSS: 2 VSS: 6261 7273 4880 6049 2 DFFX4_HS $T=1146780 502320 0 0 $X=1146600 $Y=502055
X44577 VSS: 2 VSS: 6168 6036 1701 1726 5465 2 AOI22X1 $T=1138960 510600 1 0 $X=1138780 $Y=506155
X44589 VSS: 2 VSS: 6263 7274 4880 5925 2 DFFX4_HS $T=1143560 518880 1 0 $X=1143380 $Y=514435
X44592 VSS: 2 VSS: 6266 7275 4883 4967 2 DFFX4_HS $T=1138960 518880 0 0 $X=1138780 $Y=518615
X44599 VSS: 2 VSS: 6264 8086 5258 4884 2 DFFX1_HS $T=1140340 527160 1 0 $X=1140160 $Y=522715
X44604 VSS: 2 VSS: 6268 7276 4880 4884 2 DFFX4_HS $T=1138960 527160 0 0 $X=1138780 $Y=526895
X44614 VSS: 2 VSS: 6270 7277 4883 4884 2 DFFX4_HS $T=1139880 535440 0 0 $X=1139700 $Y=535175
X44632 VSS: 2 VSS: 6272 7278 4880 4893 2 DFFX4_HS $T=1140340 552000 1 0 $X=1140160 $Y=547555
X44633 VSS: 2 VSS: 6060 4840 6055 6169 4729 2 AOI22X1 $T=1130680 552000 0 0 $X=1130500 $Y=551735
X44638 VSS: 2 VSS: 6181 7279 3904 5930 2 DFFX4_HS $T=1145400 552000 0 0 $X=1145220 $Y=551735
X44646 VSS: 2 VSS: 6175 7280 3904 5642 2 DFFX4_HS $T=1146780 560280 1 0 $X=1146600 $Y=555835
X44651 VSS: 2 VSS: 6274 7281 4883 5910 2 DFFX4_HS $T=1144940 560280 0 0 $X=1144760 $Y=560015
X44659 VSS: 2 VSS: 5936 7282 2945 6017 2 DFFX4_HS $T=1139880 568560 1 0 $X=1139700 $Y=564115
X44664 VSS: 2 VSS: 5352 7283 2945 5910 2 DFFX4_HS $T=1139420 568560 0 0 $X=1139240 $Y=568295
X44671 VSS: 2 VSS: 6276 7284 4883 6062 2 DFFX4_HS $T=1143560 576840 1 0 $X=1143380 $Y=572395
X44677 VSS: 2 VSS: 6277 7285 4883 4893 2 DFFX4_HS $T=1140800 576840 0 0 $X=1140620 $Y=576575
X44684 VSS: 2 VSS: 6279 7286 4883 5647 2 DFFX4_HS $T=1144940 585120 1 0 $X=1144760 $Y=580675
X44688 VSS: 2 VSS: 6173 6170 2006 2007 5472 2 AOI22X1 $T=1133900 585120 0 0 $X=1133720 $Y=584855
X44693 VSS: 2 VSS: 6280 3313 2 BUFX4_HS $T=1146320 585120 0 0 $X=1146140 $Y=584855
X44705 VSS: 2 VSS: 6174 7287 3904 4893 2 DFFX4_HS $T=1138040 593400 0 0 $X=1137860 $Y=593135
X44713 VSS: 2 VSS: 6176 6175 3022 3205 4226 2 AOI22X1 $T=1144020 601680 1 0 $X=1143840 $Y=597235
X44719 VSS: 2 VSS: 6283 6177 6180 6173 6176 2 NAND4X1 $T=1145860 601680 0 0 $X=1145680 $Y=601415
X44727 VSS: 2 VSS: 5799 5475 1991 1990 5936 2 AOI22X1 $T=1140340 609960 1 0 $X=1140160 $Y=605515
X44733 VSS: 2 VSS: 6178 3783 5472 5633 4969 2 AOI22X2_HS $T=1143560 609960 0 0 $X=1143380 $Y=609695
X44741 VSS: 2 VSS: 6179 6178 2 CLKBUFX2_HS $T=1144480 618240 1 0 $X=1144300 $Y=613795
X44747 VSS: 2 VSS: 6180 6181 3028 3029 4230 2 AOI22X1 $T=1143100 618240 0 0 $X=1142920 $Y=617975
X44755 VSS: 2 VSS: 5198 6182 6183 6184 6179 2 NAND4X4_HS $T=1140800 626520 1 0 $X=1140620 $Y=622075
X44773 VSS: 2 VSS: 6185 4681 5644 6063 3181 2 AOI22X2_HS $T=1141720 634800 0 0 $X=1141540 $Y=634535
X44780 VSS: 2 VSS: 6075 6185 6186 2 NAND2X2_HS $T=1138960 643080 0 180 $X=1135560 $Y=638635
X44790 VSS: 2 VSS: 6190 6189 5674 5943 6188 2 AOI22X2_HS $T=1154600 13800 1 0 $X=1154420 $Y=9355
X44793 VSS: 2 VSS: 6189 5003 2 BUFX8_HS $T=1158280 13800 1 180 $X=1152580 $Y=13535
X44798 VSS: 2 VSS: 6078 6187 6191 2 NOR2X2_HS $T=1160580 22080 0 180 $X=1157180 $Y=17635
X44802 VSS: 2 VSS: 6195 6193 6192 6087 6194 2 NAND4X2_HS $T=1154600 22080 1 180 $X=1148900 $Y=21815
X44807 VSS: 2 VSS: 6191 6190 6197 6086 6196 2 NAND4X2_HS $T=1155520 30360 0 180 $X=1149820 $Y=25915
X44814 VSS: 2 VSS: 6193 5952 5947 5208 5003 2 AOI22X1 $T=1158280 30360 0 0 $X=1158100 $Y=30095
X44815 VSS: 2 VSS: 6226 4864 2 CLKBUFX8 $T=1161040 30360 0 0 $X=1160860 $Y=30095
X44822 VSS: 2 VSS: 6288 4208 6199 6198 6289 2 AOI22X2 $T=1162880 38640 1 0 $X=1162700 $Y=34195
X44825 VSS: 2 VSS: 6085 4094 6089 6200 4208 2 AOI22X2_HS $T=1155520 38640 1 180 $X=1149820 $Y=38375
X44831 VSS: 2 VSS: 6197 4870 6199 6198 4946 2 AOI22X2_HS $T=1153680 46920 1 0 $X=1153500 $Y=42475
X44837 VSS: 2 VSS: 6194 4870 6200 6089 4946 2 AOI22X2_HS $T=1152300 46920 0 0 $X=1152120 $Y=46655
X44842 VSS: 2 VSS: 6202 6201 1991 1990 5676 2 AOI22X1 $T=1154600 55200 1 0 $X=1154420 $Y=50755
X44851 VSS: 2 VSS: 6299 6300 1991 1990 5678 2 AOI22X1 $T=1162880 55200 0 0 $X=1162700 $Y=54935
X44854 VSS: 2 VSS: 6203 6198 3039 3198 5948 2 AOI22X1 $T=1157360 63480 1 0 $X=1157180 $Y=59035
X44861 VSS: 2 VSS: 6204 5670 1701 1726 6205 2 AOI22X1 $T=1163340 63480 1 180 $X=1160400 $Y=63215
X44868 VSS: 2 VSS: 6300 8087 4463 5368 2 DFFX1_HS $T=1159660 71760 1 0 $X=1159480 $Y=67315
X44869 VSS: 2 VSS: 6201 7288 4461 5368 2 DFFX4_HS $T=1150000 71760 0 0 $X=1149820 $Y=71495
X44875 VSS: 2 VSS: 6303 7289 4396 5368 2 DFFX4_HS $T=1159200 80040 1 0 $X=1159020 $Y=75595
X44877 VSS: 2 VSS: 6095 4870 6206 6207 4946 2 AOI22X2 $T=1155980 80040 1 180 $X=1151200 $Y=79775
X44881 VSS: 2 VSS: 6100 4094 6207 6206 4208 2 AOI22X2 $T=1154600 88320 0 180 $X=1149820 $Y=83875
X44888 VSS: 2 VSS: 6198 7290 4461 6049 2 DFFX4_HS $T=1148160 96600 1 0 $X=1147980 $Y=92155
X44889 VSS: 2 VSS: 6286 8088 4463 5996 2 DFFX1_HS $T=1159660 96600 1 0 $X=1159480 $Y=92155
X44893 VSS: 2 VSS: 6208 6207 3039 3198 6091 2 AOI22X1 $T=1155520 96600 0 0 $X=1155340 $Y=96335
X44896 VSS: 2 VSS: 5948 7291 4461 5925 2 DFFX4_HS $T=1147700 104880 1 0 $X=1147520 $Y=100435
X44900 VSS: 2 VSS: 6304 7292 4396 5996 2 DFFX4_HS $T=1162420 104880 1 0 $X=1162240 $Y=100435
X44902 VSS: 2 VSS: 6207 7293 4396 6049 2 DFFX4_HS $T=1150920 104880 0 0 $X=1150740 $Y=104615
X44904 VSS: 2 VSS: 5964 5038 5956 6209 5282 2 AOI22X2_HS $T=1154600 113160 0 180 $X=1148900 $Y=108715
X44908 VSS: 2 VSS: 6108 3870 5956 6209 4839 2 AOI22X2_HS $T=1152760 113160 1 180 $X=1147060 $Y=112895
X44916 VSS: 2 VSS: 6313 7294 4530 5368 2 DFFX4_HS $T=1157820 121440 1 0 $X=1157640 $Y=116995
X44919 VSS: 2 VSS: 6109 7295 4530 6049 2 DFFX4_HS $T=1151840 121440 0 0 $X=1151660 $Y=121175
X44927 VSS: 2 VSS: 6210 6109 3039 3198 6114 2 AOI22X1 $T=1158280 129720 0 0 $X=1158100 $Y=129455
X44931 VSS: 2 VSS: 5971 4870 6110 6109 4946 2 AOI22X2_HS $T=1157820 138000 0 180 $X=1152120 $Y=133555
X44936 VSS: 2 VSS: 6199 7296 4461 5396 2 DFFX4_HS $T=1154600 138000 0 0 $X=1154420 $Y=137735
X44940 VSS: 2 VSS: 6200 8089 4463 5396 2 DFFX1_HS $T=1153680 146280 1 0 $X=1153500 $Y=141835
X44945 VSS: 2 VSS: 6206 7297 4396 5396 2 DFFX4_HS $T=1155060 146280 0 0 $X=1154880 $Y=146015
X44948 VSS: 2 VSS: 6110 7298 4530 5396 2 DFFX4_HS $T=1152760 154560 1 0 $X=1152580 $Y=150115
X44951 VSS: 2 VSS: 6212 6211 3039 3198 6117 2 AOI22X1 $T=1153220 154560 0 0 $X=1153040 $Y=154295
X44955 VSS: 2 VSS: 6213 4094 6211 6120 4208 2 AOI22X2 $T=1148620 162840 1 0 $X=1148440 $Y=158395
X44965 VSS: 2 VSS: 6211 8090 4331 6049 2 DFFX1_HS $T=1157360 171120 1 0 $X=1157180 $Y=166675
X44972 VSS: 2 VSS: 6214 3870 5811 6124 4839 2 AOI22X2 $T=1149080 179400 1 0 $X=1148900 $Y=174955
X44977 VSS: 2 VSS: 6215 6119 6213 6127 6214 2 NAND4X2_HS $T=1148620 179400 0 0 $X=1148440 $Y=179135
X44981 VSS: 2 VSS: 6331 8091 4331 5368 2 DFFX1_HS $T=1160120 179400 0 0 $X=1159940 $Y=179135
X44982 VSS: 2 VSS: 6216 5510 6217 2 NOR2X2_HS $T=1147700 187680 1 0 $X=1147520 $Y=183235
X44985 VSS: 2 VSS: 6120 8092 4331 5396 2 DFFX1_HS $T=1155060 187680 1 0 $X=1154880 $Y=183235
X44989 VSS: 2 VSS: 6136 5962 2 CLKBUFX8 $T=1153220 187680 0 0 $X=1153040 $Y=187415
X44990 VSS: 2 VSS: 6219 6218 6215 2 NOR2X2_HS $T=1161500 187680 1 180 $X=1158100 $Y=187415
X44996 VSS: 2 VSS: 6125 8093 4331 6136 2 DFFX1_HS $T=1156900 195960 1 0 $X=1156720 $Y=191515
X45004 VSS: 2 VSS: 6337 5253 2 CLKBUFX4 $T=1161500 204240 1 0 $X=1161320 $Y=199795
X45017 VSS: 2 VSS: 6220 7299 4920 5925 2 DFFX4_HS $T=1153680 212520 0 0 $X=1153500 $Y=212255
X45020 VSS: 2 VSS: 6344 7300 4920 5368 2 DFFX4_HS $T=1156440 220800 1 0 $X=1156260 $Y=216355
X45028 VSS: 2 VSS: 6345 7301 4920 6049 2 DFFX4_HS $T=1155520 229080 1 0 $X=1155340 $Y=224635
X45031 VSS: 2 VSS: 6222 7302 4920 6136 2 DFFX4_HS $T=1150000 229080 0 0 $X=1149820 $Y=228815
X45038 VSS: 2 VSS: 6223 7303 4920 5396 2 DFFX4_HS $T=1150920 237360 0 0 $X=1150740 $Y=237095
X45040 VSS: 2 VSS: 6141 6126 2 CLKBUFX8 $T=1149540 245640 1 0 $X=1149360 $Y=241195
X45042 VSS: 2 VSS: 6339 7304 4920 5642 2 DFFX4_HS $T=1155520 245640 1 0 $X=1155340 $Y=241195
X45053 VSS: 2 VSS: 6221 7305 4920 6141 2 DFFX4_HS $T=1154600 253920 0 0 $X=1154420 $Y=253655
X45060 VSS: 2 VSS: 5839 6140 2317 2343 5998 2 AOI22X1 $T=1154600 262200 1 180 $X=1151660 $Y=261935
X45065 VSS: 2 VSS: 6224 7306 4536 5396 2 DFFX4_HS $T=1153220 270480 1 0 $X=1153040 $Y=266035
X45067 VSS: 2 VSS: 5998 8094 4964 6226 2 DFFX1_HS $T=1155520 270480 0 0 $X=1155340 $Y=270215
X45071 VSS: 2 VSS: 5550 8095 1824 6136 2 DFFX1_HS $T=1156440 278760 1 0 $X=1156260 $Y=274315
X45075 VSS: 2 VSS: 6228 7307 4536 6136 2 DFFX4_HS $T=1153680 278760 0 0 $X=1153500 $Y=278495
X45076 VSS: 2 VSS: 6229 7308 4536 5925 2 DFFX4_HS $T=1150000 287040 1 0 $X=1149820 $Y=282595
X45084 VSS: 2 VSS: 6230 7309 4536 6049 2 DFFX4_HS $T=1154600 295320 1 0 $X=1154420 $Y=290875
X45091 VSS: 2 VSS: 6355 6230 3039 3198 6229 2 AOI22X1 $T=1163340 295320 0 0 $X=1163160 $Y=295055
X45094 VSS: 2 VSS: 5870 8096 1824 6226 2 DFFX1_HS $T=1155520 303600 1 0 $X=1155340 $Y=299155
X45097 VSS: 2 VSS: 6231 5550 2555 2564 5571 2 AOI22X1 $T=1148620 303600 0 0 $X=1148440 $Y=303335
X45105 VSS: 2 VSS: 6232 7310 4536 6141 2 DFFX4_HS $T=1152300 311880 1 0 $X=1152120 $Y=307435
X45109 VSS: 2 VSS: 6358 7311 4536 5642 2 DFFX4_HS $T=1155980 311880 0 0 $X=1155800 $Y=311615
X45116 VSS: 2 VSS: 6233 5859 2317 2319 5870 2 AOI22X1 $T=1152300 320160 0 0 $X=1152120 $Y=319895
X45124 VSS: 2 VSS: 6147 6233 6235 6231 6234 2 NAND4X1 $T=1156900 328440 1 0 $X=1156720 $Y=323995
X45129 VSS: 2 VSS: 5859 8097 1824 5923 2 DFFX1_HS $T=1152300 328440 0 0 $X=1152120 $Y=328175
X45133 VSS: 2 VSS: 6140 8098 4964 5923 2 DFFX1_HS $T=1151840 336720 1 0 $X=1151660 $Y=332275
X45137 VSS: 2 VSS: 6234 6153 2320 2558 5414 2 AOI22X1 $T=1155980 336720 0 0 $X=1155800 $Y=336455
X45144 VSS: 2 VSS: 6235 6154 2606 2808 6012 2 AOI22X1 $T=1154140 345000 1 0 $X=1153960 $Y=340555
X45149 VSS: 2 VSS: 3183 2606 2 CLKBUFX4 $T=1163340 345000 0 0 $X=1163160 $Y=344735
X45151 VSS: 2 VSS: 6237 7312 4504 5930 2 DFFX4_HS $T=1150920 353280 1 0 $X=1150740 $Y=348835
X45153 VSS: 2 VSS: 6368 7313 4504 5615 2 DFFX4_HS $T=1162880 353280 1 0 $X=1162700 $Y=348835
X45160 VSS: 2 VSS: 6154 8099 1824 5647 2 DFFX1_HS $T=1150920 361560 1 0 $X=1150740 $Y=357115
X45163 VSS: 2 VSS: 6363 7314 4536 5647 2 DFFX4_HS $T=1162880 361560 1 0 $X=1162700 $Y=357115
X45164 VSS: 2 VSS: 6239 7315 4536 6062 2 DFFX4_HS $T=1147240 361560 0 0 $X=1147060 $Y=361295
X45167 VSS: 2 VSS: 6371 7316 4504 5647 2 DFFX4_HS $T=1162880 361560 0 0 $X=1162700 $Y=361295
X45173 VSS: 2 VSS: 6238 7317 4504 6062 2 DFFX4_HS $T=1151840 369840 0 0 $X=1151660 $Y=369575
X45174 VSS: 2 VSS: 6366 7318 4536 6017 2 DFFX4_HS $T=1163340 369840 0 0 $X=1163160 $Y=369575
X45181 VSS: 2 VSS: 6240 7319 4504 5642 2 DFFX4_HS $T=1150000 378120 0 0 $X=1149820 $Y=377855
X45183 VSS: 2 VSS: 6370 7320 4504 6017 2 DFFX4_HS $T=1161960 378120 0 0 $X=1161780 $Y=377855
X45186 VSS: 2 VSS: 6375 7321 4504 6136 2 DFFX4_HS $T=1155520 386400 1 0 $X=1155340 $Y=381955
X45193 VSS: 2 VSS: 6241 7322 4504 6141 2 DFFX4_HS $T=1152300 394680 1 0 $X=1152120 $Y=390235
X45194 VSS: 2 VSS: 6380 7323 4504 6049 2 DFFX4_HS $T=1155520 394680 0 0 $X=1155340 $Y=394415
X45200 VSS: 2 VSS: 6383 8100 5258 6141 2 DFFX1_HS $T=1156440 402960 0 0 $X=1156260 $Y=402695
X45205 VSS: 2 VSS: 6245 6244 3039 3198 6243 2 AOI22X1 $T=1157360 411240 1 0 $X=1157180 $Y=406795
X45209 VSS: 2 VSS: 6244 8101 5258 6049 2 DFFX1_HS $T=1155980 411240 0 0 $X=1155800 $Y=410975
X45213 VSS: 2 VSS: 6161 8102 4466 5647 2 DFFX1_HS $T=1158740 419520 1 0 $X=1158560 $Y=415075
X45215 VSS: 2 VSS: 6246 8103 5258 6136 2 DFFX1_HS $T=1151380 419520 0 0 $X=1151200 $Y=419255
X45219 VSS: 2 VSS: 6247 8104 5258 5930 2 DFFX1_HS $T=1153220 427800 1 0 $X=1153040 $Y=423355
X45223 VSS: 2 VSS: 6248 8105 5258 5647 2 DFFX1_HS $T=1153220 427800 0 0 $X=1153040 $Y=427535
X45228 VSS: 2 VSS: 6249 8106 5258 6062 2 DFFX1_HS $T=1153220 436080 1 0 $X=1153040 $Y=431635
X45236 VSS: 2 VSS: 6390 4681 6250 6249 3181 2 AOI22X2_HS $T=1168860 436080 1 180 $X=1163160 $Y=435815
X45240 VSS: 2 VSS: 6041 6162 6161 2596 2595 2 AOI22X2 $T=1151840 444360 1 180 $X=1147060 $Y=444095
X45246 VSS: 2 VSS: 6163 6162 3028 3029 5905 2 AOI22X1 $T=1147700 452640 1 0 $X=1147520 $Y=448195
X45251 VSS: 2 VSS: 6393 8107 5258 5910 2 DFFX1_HS $T=1160580 452640 1 0 $X=1160400 $Y=448195
X45253 VSS: 2 VSS: 6164 6030 3022 3205 5767 2 AOI22X1 $T=1148620 452640 0 0 $X=1148440 $Y=452375
X45257 VSS: 2 VSS: 6394 7324 4504 5910 2 DFFX4_HS $T=1159200 452640 0 0 $X=1159020 $Y=452375
X45263 VSS: 2 VSS: 6396 4681 6251 6252 3181 2 AOI22X2 $T=1159660 460920 1 0 $X=1159480 $Y=456475
X45266 VSS: 2 VSS: 6253 7325 4880 5930 2 DFFX4_HS $T=1152760 460920 0 0 $X=1152580 $Y=460655
X45269 VSS: 2 VSS: 6252 7326 4880 6062 2 DFFX4_HS $T=1152300 469200 1 0 $X=1152120 $Y=464755
X45272 VSS: 2 VSS: 6251 7327 4880 5642 2 DFFX4_HS $T=1155520 469200 0 0 $X=1155340 $Y=468935
X45275 VSS: 2 VSS: 6254 7328 4880 5647 2 DFFX4_HS $T=1152300 477480 1 0 $X=1152120 $Y=473035
X45276 VSS: 2 VSS: 6255 7329 4504 5098 2 DFFX4_HS $T=1147700 477480 0 0 $X=1147520 $Y=477215
X45279 VSS: 2 VSS: 6400 7330 4880 5923 2 DFFX4_HS $T=1161960 477480 0 0 $X=1161780 $Y=477215
X45282 VSS: 2 VSS: 6398 7331 4880 6017 2 DFFX4_HS $T=1161500 485760 1 0 $X=1161320 $Y=481315
X45285 VSS: 2 VSS: 6256 8108 5258 5098 2 DFFX1_HS $T=1150000 485760 0 0 $X=1149820 $Y=485495
X45287 VSS: 2 VSS: 6402 7332 4883 5923 2 DFFX4_HS $T=1161040 485760 0 0 $X=1160860 $Y=485495
X45292 VSS: 2 VSS: 6401 7333 4880 6141 2 DFFX4_HS $T=1159660 494040 1 0 $X=1159480 $Y=489595
X45295 VSS: 2 VSS: 6259 7334 4880 6136 2 DFFX4_HS $T=1154600 494040 0 0 $X=1154420 $Y=493775
X45297 VSS: 2 VSS: 6260 7335 4880 5098 2 DFFX4_HS $T=1148160 502320 1 0 $X=1147980 $Y=497875
X45298 VSS: 2 VSS: 6405 7336 4883 6136 2 DFFX4_HS $T=1159660 502320 1 0 $X=1159480 $Y=497875
X45303 VSS: 2 VSS: 6262 7337 4883 6049 2 DFFX4_HS $T=1153220 510600 1 0 $X=1153040 $Y=506155
X45308 VSS: 2 VSS: 6408 4258 3785 6263 6401 2 AOI22X2_HS $T=1160580 510600 0 0 $X=1160400 $Y=510335
X45314 VSS: 2 VSS: 6265 7338 4883 5925 2 DFFX4_HS $T=1151840 518880 0 0 $X=1151660 $Y=518615
X45316 VSS: 2 VSS: 6267 7339 4883 5098 2 DFFX4_HS $T=1149540 527160 1 0 $X=1149360 $Y=522715
X45319 VSS: 2 VSS: 6407 8109 5258 5102 2 DFFX1_HS $T=1162420 527160 1 0 $X=1162240 $Y=522715
X45322 VSS: 2 VSS: 6269 7340 4880 5102 2 DFFX4_HS $T=1152760 527160 0 0 $X=1152580 $Y=526895
X45330 VSS: 2 VSS: 6414 7341 4880 5910 2 DFFX4_HS $T=1155520 535440 0 0 $X=1155340 $Y=535175
X45333 VSS: 2 VSS: 6170 7342 3904 5102 2 DFFX4_HS $T=1150000 543720 1 0 $X=1149820 $Y=539275
X45338 VSS: 2 VSS: 6271 7343 4883 5930 2 DFFX4_HS $T=1149080 543720 0 0 $X=1148900 $Y=543455
X45342 VSS: 2 VSS: 6273 7344 4883 5642 2 DFFX4_HS $T=1154600 552000 1 0 $X=1154420 $Y=547555
X45348 VSS: 2 VSS: 6419 7345 4883 6017 2 DFFX4_HS $T=1156900 560280 0 0 $X=1156720 $Y=560015
X45353 VSS: 2 VSS: 6421 7346 3904 6017 2 DFFX4_HS $T=1161500 568560 1 0 $X=1161320 $Y=564115
X45355 VSS: 2 VSS: 6275 7347 3904 5910 2 DFFX4_HS $T=1152760 568560 0 0 $X=1152580 $Y=568295
X45360 VSS: 2 VSS: 6278 7348 3904 6062 2 DFFX4_HS $T=1153220 576840 0 0 $X=1153040 $Y=576575
X45363 VSS: 2 VSS: 6428 3491 6055 6169 4127 2 AOI22X1_HS $T=1161960 585120 1 0 $X=1161780 $Y=580675
X45368 VSS: 2 VSS: 6429 7349 3904 5647 2 DFFX4_HS $T=1160120 585120 0 0 $X=1159940 $Y=584855
X45370 VSS: 2 VSS: 6281 3541 6170 5467 6280 2 AOI22X2_HS $T=1149540 593400 1 0 $X=1149360 $Y=588955
X45381 VSS: 2 VSS: 6071 6282 6430 6431 6432 2 NAND4X4_HS $T=1161500 601680 1 0 $X=1161320 $Y=597235
X45391 VSS: 2 VSS: 6282 4681 6175 6278 3181 2 AOI22X2_HS $T=1160580 609960 1 0 $X=1160400 $Y=605515
X45413 VSS: 2 VSS: 6435 2596 6429 6181 2595 2 AOI22X2_HS $T=1161040 626520 0 0 $X=1160860 $Y=626255
X45415 VSS: 2 VSS: 5941 4096 6063 5644 4338 2 AOI22X2_HS $T=1151380 634800 1 0 $X=1151200 $Y=630355
X45425 VSS: 2 VSS: 6186 5800 6015 2 NAND2X4_HS $T=1157360 643080 1 0 $X=1157180 $Y=638635
X45433 VSS: 2 VSS: 6439 5665 6438 2 NOR2X4_HS $T=1177600 13800 1 0 $X=1177420 $Y=9355
X45440 VSS: 2 VSS: 6188 5208 2 BUFX2_HS $T=1169780 13800 1 180 $X=1166840 $Y=13535
X45458 VSS: 2 VSS: 6284 5943 2555 2564 6285 2 AOI22X1 $T=1170700 22080 1 180 $X=1167760 $Y=21815
X45469 VSS: 2 VSS: 6287 5947 2555 2564 6286 2 AOI22X1 $T=1173460 30360 1 0 $X=1173280 $Y=25915
X45477 VSS: 2 VSS: 6442 7350 4461 6226 2 DFFX4_HS $T=1173920 30360 0 0 $X=1173740 $Y=30095
X45490 VSS: 2 VSS: 6289 4094 2 CLKBUFX2 $T=1170700 38640 1 180 $X=1168220 $Y=38375
X45492 VSS: 2 VSS: 6290 4819 2 CLKBUFX8 $T=1171160 38640 0 0 $X=1170980 $Y=38375
X45498 VSS: 2 VSS: 2069 6292 2 BUFX16_HS $T=1175760 46920 0 180 $X=1165460 $Y=42475
X45501 VSS: 2 VSS: 6449 6293 5319 6287 6291 2 NAND4X1 $T=1178520 46920 1 0 $X=1178340 $Y=42475
X45509 VSS: 2 VSS: 6296 6294 5321 6284 6295 2 NAND4X1 $T=1173460 46920 0 0 $X=1173280 $Y=46655
X45518 VSS: 2 VSS: 6297 6298 6202 6203 6204 2 NAND4X1 $T=1174380 55200 1 0 $X=1174200 $Y=50755
X45528 VSS: 2 VSS: 6291 5679 2320 2558 6455 2 AOI22X1 $T=1181740 55200 1 180 $X=1178800 $Y=54935
X45537 VSS: 2 VSS: 6295 5677 2320 2558 6456 2 AOI22X1 $T=1181280 63480 0 180 $X=1178340 $Y=59035
X45545 VSS: 2 VSS: 6302 5479 1701 1726 6301 2 AOI22X1 $T=1175760 63480 0 0 $X=1175580 $Y=63215
X45550 VSS: 2 VSS: 6301 8110 4463 5278 2 DFFX1_HS $T=1168860 71760 1 0 $X=1168680 $Y=67315
X45556 VSS: 2 VSS: 6205 7351 4461 5278 2 DFFX4_HS $T=1167020 71760 0 0 $X=1166840 $Y=71495
X45570 VSS: 2 VSS: 6305 5955 2555 2564 6304 2 AOI22X1 $T=1178060 80040 1 180 $X=1175120 $Y=79775
X45585 VSS: 2 VSS: 6306 6303 1991 1990 5680 2 AOI22X1 $T=1166560 88320 0 0 $X=1166380 $Y=88055
X45592 VSS: 2 VSS: 6285 7352 4461 5996 2 DFFX4_HS $T=1168860 96600 1 0 $X=1168680 $Y=92155
X45600 VSS: 2 VSS: 6307 6308 6306 6208 6309 2 NAND4X1 $T=1171620 96600 0 0 $X=1171440 $Y=96335
X45613 VSS: 2 VSS: 6310 7353 4396 5278 2 DFFX4_HS $T=1167480 104880 0 0 $X=1167300 $Y=104615
X45621 VSS: 2 VSS: 6309 5492 1701 1726 6310 2 AOI22X1 $T=1174380 113160 0 180 $X=1171440 $Y=108715
X45632 VSS: 2 VSS: 6312 5961 2555 2564 6311 2 AOI22X1 $T=1177140 113160 1 180 $X=1174200 $Y=112895
X45639 VSS: 2 VSS: 6311 7354 4530 5996 2 DFFX4_HS $T=1170700 121440 1 0 $X=1170520 $Y=116995
X45646 VSS: 2 VSS: 6316 6314 5372 6312 6315 2 NAND4X1 $T=1175760 121440 1 180 $X=1172820 $Y=121175
X45654 VSS: 2 VSS: 6317 6313 1991 1990 5690 2 AOI22X1 $T=1165180 129720 1 0 $X=1165000 $Y=125275
X45667 VSS: 2 VSS: 6318 6474 5969 6475 5967 2 NAND4X1 $T=1182200 129720 1 180 $X=1179260 $Y=129455
X45675 VSS: 2 VSS: 6321 6320 6317 6210 6319 2 NAND4X1 $T=1178060 138000 0 180 $X=1175120 $Y=133555
X45684 VSS: 2 VSS: 6322 6316 6318 6321 2 NOR3X1 $T=1174380 138000 0 0 $X=1174200 $Y=137735
X45692 VSS: 2 VSS: 6319 5501 1701 1726 6323 2 AOI22X1 $T=1175760 146280 0 180 $X=1172820 $Y=141835
X45700 VSS: 2 VSS: 6482 7355 4920 5278 2 DFFX4_HS $T=1171160 146280 0 0 $X=1170980 $Y=146015
X45704 VSS: 2 VSS: 6324 8111 4331 5278 2 DFFX1_HS $T=1164260 154560 1 0 $X=1164080 $Y=150115
X45705 VSS: 2 VSS: 6323 7356 4530 5278 2 DFFX4_HS $T=1173460 154560 1 0 $X=1173280 $Y=150115
X45712 VSS: 2 VSS: 6326 5811 2317 2319 6325 2 AOI22X1 $T=1173000 154560 0 0 $X=1172820 $Y=154295
X45722 VSS: 2 VSS: 6327 5504 1701 1726 6324 2 AOI22X1 $T=1177140 162840 0 180 $X=1174200 $Y=158395
X45731 VSS: 2 VSS: 6330 6326 5376 6329 6328 2 NAND4X1 $T=1175300 162840 0 0 $X=1175120 $Y=162575
X45744 VSS: 2 VSS: 6332 6331 1991 1990 5702 2 AOI22X1 $T=1165180 171120 0 0 $X=1165000 $Y=170855
X45753 VSS: 2 VSS: 6333 6335 6332 6212 6327 2 NAND4X1 $T=1165640 179400 1 0 $X=1165460 $Y=174955
X45758 VSS: 2 VSS: 6488 6330 6334 6333 2 NOR3X1 $T=1178060 179400 1 0 $X=1177880 $Y=174955
X45765 VSS: 2 VSS: 6336 8112 4331 5996 2 DFFX1_HS $T=1172080 179400 0 0 $X=1171900 $Y=179135
X45773 VSS: 2 VSS: 6329 6125 2555 2564 6336 2 AOI22X1 $T=1178980 187680 0 180 $X=1176040 $Y=183235
X45782 VSS: 2 VSS: 6489 4749 2 BUFX8 $T=1176680 187680 0 0 $X=1176500 $Y=187415
X45791 VSS: 2 VSS: 6490 6129 3183 2808 5985 2 AOI22X1 $T=1178520 195960 1 0 $X=1178340 $Y=191515
X45811 VSS: 2 VSS: 6340 5985 6339 5273 3181 2 AOI22X1_HS $T=1165640 204240 0 0 $X=1165460 $Y=203975
X45821 VSS: 2 VSS: 6341 4338 6339 5985 5383 2 AOI22X2_HS $T=1173920 212520 0 180 $X=1168220 $Y=208075
X45831 VSS: 2 VSS: 6342 6343 6337 2 NAND2X2 $T=1178060 212520 0 0 $X=1177880 $Y=212255
X45838 VSS: 2 VSS: 6338 5390 2 CLKBUFX2 $T=1173460 220800 1 0 $X=1173280 $Y=216355
X45846 VSS: 2 VSS: 6346 6345 3039 3198 6220 2 AOI22X1 $T=1166560 220800 0 0 $X=1166380 $Y=220535
X45854 VSS: 2 VSS: 6347 7357 4920 5996 2 DFFX4_HS $T=1170700 229080 1 0 $X=1170520 $Y=224635
X45862 VSS: 2 VSS: 6348 6130 3028 3029 6221 2 AOI22X1 $T=1172080 229080 0 0 $X=1171900 $Y=228815
X45869 VSS: 2 VSS: 6349 7358 4920 5810 2 DFFX4_HS $T=1164260 237360 1 0 $X=1164080 $Y=232915
X45877 VSS: 2 VSS: 6350 6339 3022 3205 6349 2 AOI22X1 $T=1173460 237360 0 0 $X=1173280 $Y=237095
X45891 VSS: 2 VSS: 6351 6223 6345 4946 5719 2 AOI22X1_HS $T=1172540 245640 0 0 $X=1172360 $Y=245375
X45910 VSS: 2 VSS: 6507 5285 6220 6221 4877 2 AOI22X2 $T=1177600 253920 0 0 $X=1177420 $Y=253655
X45920 VSS: 2 VSS: 6504 3785 6220 6221 4221 2 AOI22X2_HS $T=1178980 262200 1 0 $X=1178800 $Y=257755
X45927 VSS: 2 VSS: 5845 8113 4964 5446 2 DFFX1_HS $T=1173920 262200 0 0 $X=1173740 $Y=261935
X45934 VSS: 2 VSS: 6352 5719 4946 6230 6224 2 AOI22X2 $T=1173920 270480 1 0 $X=1173740 $Y=266035
X45942 VSS: 2 VSS: 5856 8114 4964 6290 2 DFFX1_HS $T=1169780 270480 0 0 $X=1169600 $Y=270215
X45949 VSS: 2 VSS: 5866 8115 1824 6290 2 DFFX1_HS $T=1169780 278760 1 0 $X=1169600 $Y=274315
X45957 VSS: 2 VSS: 5858 8116 1824 5446 2 DFFX1_HS $T=1173460 278760 0 0 $X=1173280 $Y=278495
X45974 VSS: 2 VSS: 6510 3785 6229 6232 4221 2 AOI22X2_HS $T=1179440 287040 0 0 $X=1179260 $Y=286775
X45980 VSS: 2 VSS: 6353 7359 4536 5810 2 DFFX4_HS $T=1168860 295320 1 0 $X=1168680 $Y=290875
X45988 VSS: 2 VSS: 6493 7360 4920 6354 2 DFFX4_HS $T=1176220 295320 0 0 $X=1176040 $Y=295055
X45995 VSS: 2 VSS: 6343 7361 4920 5615 2 DFFX4_HS $T=1169320 303600 1 0 $X=1169140 $Y=299155
X46001 VSS: 2 VSS: 6356 7362 4536 5996 2 DFFX4_HS $T=1165640 303600 0 0 $X=1165460 $Y=303335
X46009 VSS: 2 VSS: 6357 6236 3028 3029 6232 2 AOI22X1 $T=1173000 311880 1 0 $X=1172820 $Y=307435
X46018 VSS: 2 VSS: 6359 6358 3022 3205 6353 2 AOI22X1 $T=1179440 311880 1 180 $X=1176500 $Y=311615
X46025 VSS: 2 VSS: 6360 5274 5273 6358 6239 2 AOI22X2 $T=1167480 320160 1 0 $X=1167300 $Y=315715
X46036 VSS: 2 VSS: 6518 4338 6358 6239 5383 2 AOI22X2_HS $T=1175760 320160 0 0 $X=1175580 $Y=319895
X46048 VSS: 2 VSS: 6361 7363 4536 5615 2 DFFX4_HS $T=1165180 328440 0 0 $X=1165000 $Y=328175
X46049 VSS: 2 VSS: 6520 7364 4536 6354 2 DFFX4_HS $T=1176680 328440 0 0 $X=1176500 $Y=328175
X46055 VSS: 2 VSS: 6362 7365 4920 5923 2 DFFX4_HS $T=1167480 336720 1 0 $X=1167300 $Y=332275
X46066 VSS: 2 VSS: 6364 6363 2606 2808 6239 2 AOI22X1 $T=1176680 336720 0 0 $X=1176500 $Y=336455
X46074 VSS: 2 VSS: 6365 7366 4536 5923 2 DFFX4_HS $T=1167480 345000 1 0 $X=1167300 $Y=340555
X46087 VSS: 2 VSS: 6367 5390 2 CLKBUFX2 $T=1176220 353280 1 0 $X=1176040 $Y=348835
X46089 VSS: 2 VSS: 6524 7367 4504 6354 2 DFFX4_HS $T=1179440 353280 1 0 $X=1179260 $Y=348835
X46094 VSS: 2 VSS: 6369 6238 6240 4681 5274 2 AOI22X1_HS $T=1167940 353280 0 0 $X=1167760 $Y=353015
X46126 VSS: 2 VSS: 6372 4096 6238 6240 4338 2 AOI22X2 $T=1167480 378120 1 0 $X=1167300 $Y=373675
X46136 VSS: 2 VSS: 6374 6237 3028 3029 6241 2 AOI22X1 $T=1180820 378120 1 180 $X=1177880 $Y=377855
X46144 VSS: 2 VSS: 6376 6240 3022 3205 6377 2 AOI22X1 $T=1178520 386400 0 180 $X=1175580 $Y=381955
X46150 VSS: 2 VSS: 6378 7368 4504 5923 2 DFFX4_HS $T=1166560 386400 0 0 $X=1166380 $Y=386135
X46156 VSS: 2 VSS: 6377 7369 4504 5810 2 DFFX4_HS $T=1164260 394680 1 0 $X=1164080 $Y=390235
X46158 VSS: 2 VSS: 6153 8117 1824 6354 2 DFFX1_HS $T=1177600 394680 1 0 $X=1177420 $Y=390235
X46163 VSS: 2 VSS: 6373 6380 3039 3198 6242 2 AOI22X1 $T=1168860 394680 0 0 $X=1168680 $Y=394415
X46167 VSS: 2 VSS: 6379 3785 6242 6241 4258 2 AOI22X2_HS $T=1182200 394680 1 180 $X=1176500 $Y=394415
X46174 VSS: 2 VSS: 6381 5285 6242 6241 3453 2 AOI22X2 $T=1173460 402960 1 0 $X=1173280 $Y=398515
X46182 VSS: 2 VSS: 6533 7370 4504 6382 2 DFFX4_HS $T=1173460 402960 0 0 $X=1173280 $Y=402695
X46191 VSS: 2 VSS: 6538 3453 6383 6243 5285 2 AOI22X1_HS $T=1178520 411240 1 0 $X=1178340 $Y=406795
X46196 VSS: 2 VSS: 6384 8118 5258 5923 2 DFFX1_HS $T=1166100 411240 0 0 $X=1165920 $Y=410975
X46203 VSS: 2 VSS: 6385 8119 5258 6382 2 DFFX1_HS $T=1171620 419520 1 0 $X=1171440 $Y=415075
X46212 VSS: 2 VSS: 6386 6247 3028 3029 6383 2 AOI22X1 $T=1173920 419520 1 180 $X=1170980 $Y=419255
X46214 VSS: 2 VSS: 6382 5167 2 CLKBUFX2 $T=1174380 419520 0 0 $X=1174200 $Y=419255
X46221 VSS: 2 VSS: 6387 8120 5258 5810 2 DFFX1_HS $T=1171620 427800 1 0 $X=1171440 $Y=423355
X46226 VSS: 2 VSS: 6388 8121 5258 6017 2 DFFX1_HS $T=1164720 427800 0 0 $X=1164540 $Y=427535
X46235 VSS: 2 VSS: 6389 6250 3022 3205 6387 2 AOI22X1 $T=1178060 436080 0 180 $X=1175120 $Y=431635
X46248 VSS: 2 VSS: 6391 4338 6250 6249 4096 2 AOI22X2 $T=1169780 444360 1 0 $X=1169600 $Y=439915
X46256 VSS: 2 VSS: 6392 5390 2 BUFX4_HS $T=1169320 444360 0 0 $X=1169140 $Y=444095
X46267 VSS: 2 VSS: 6551 6392 6247 6248 6069 2 AOI22X1_HS $T=1178520 452640 1 0 $X=1178340 $Y=448195
X46271 VSS: 2 VSS: 6395 8122 5258 5615 2 DFFX1_HS $T=1170700 452640 0 0 $X=1170520 $Y=452375
X46281 VSS: 2 VSS: 6397 6069 6254 6253 6392 2 AOI22X2_HS $T=1174840 460920 1 0 $X=1174660 $Y=456475
X46288 VSS: 2 VSS: 6354 5847 2 CLKBUFX4 $T=1172540 460920 0 0 $X=1172360 $Y=460655
X46297 VSS: 2 VSS: 6399 7371 4880 5615 2 DFFX4_HS $T=1167020 469200 1 0 $X=1166840 $Y=464755
X46298 VSS: 2 VSS: 6557 7372 4880 6354 2 DFFX4_HS $T=1178520 469200 1 0 $X=1178340 $Y=464755
X46304 VSS: 2 VSS: 5620 8123 4466 6382 2 DFFX1_HS $T=1171160 469200 0 0 $X=1170980 $Y=468935
X46313 VSS: 2 VSS: 6560 4096 6252 6251 4338 2 AOI22X2_HS $T=1177600 477480 1 0 $X=1177420 $Y=473035
X46343 VSS: 2 VSS: 6404 6251 3022 3205 6403 2 AOI22X1 $T=1178980 494040 1 180 $X=1176040 $Y=493775
X46349 VSS: 2 VSS: 6403 7373 4880 5810 2 DFFX4_HS $T=1171160 502320 1 0 $X=1170980 $Y=497875
X46354 VSS: 2 VSS: 6406 7374 4883 5810 2 DFFX4_HS $T=1166560 502320 0 0 $X=1166380 $Y=502055
X46368 VSS: 2 VSS: 6409 8124 5258 4968 2 DFFX1_HS $T=1169780 510600 0 0 $X=1169600 $Y=510335
X46376 VSS: 2 VSS: 6410 6261 3039 3198 6263 2 AOI22X1 $T=1175300 518880 1 0 $X=1175120 $Y=514435
X46381 VSS: 2 VSS: 6411 7375 4880 4968 2 DFFX4_HS $T=1164260 518880 0 0 $X=1164080 $Y=518615
X46389 VSS: 2 VSS: 6567 7376 4880 6382 2 DFFX4_HS $T=1174380 527160 1 0 $X=1174200 $Y=522715
X46395 VSS: 2 VSS: 6412 7377 4883 4968 2 DFFX4_HS $T=1167940 527160 0 0 $X=1167760 $Y=526895
X46403 VSS: 2 VSS: 6413 5285 6265 6257 3453 2 AOI22X2 $T=1176220 535440 0 180 $X=1171440 $Y=530995
X46409 VSS: 2 VSS: 6415 7378 4883 6382 2 DFFX4_HS $T=1170700 535440 0 0 $X=1170520 $Y=535175
X46414 VSS: 2 VSS: 6416 7379 4883 5102 2 DFFX4_HS $T=1163800 543720 1 0 $X=1163620 $Y=539275
X46415 VSS: 2 VSS: 6572 7380 3904 6382 2 DFFX4_HS $T=1175300 543720 1 0 $X=1175120 $Y=539275
X46422 VSS: 2 VSS: 6417 6262 3039 3198 6265 2 AOI22X1 $T=1172080 543720 0 0 $X=1171900 $Y=543455
X46430 VSS: 2 VSS: 5475 7381 2945 6029 2 DFFX4_HS $T=1168860 552000 1 0 $X=1168680 $Y=547555
X46437 VSS: 2 VSS: 6418 6273 3022 3205 6406 2 AOI22X1 $T=1173460 552000 1 180 $X=1170520 $Y=551735
X46452 VSS: 2 VSS: 6420 6271 3028 3029 6257 2 AOI22X1 $T=1175760 560280 0 0 $X=1175580 $Y=560015
X46467 VSS: 2 VSS: 6422 6279 3183 2808 6276 2 AOI22X1 $T=1176220 568560 0 0 $X=1176040 $Y=568295
X46473 VSS: 2 VSS: 6423 2997 4657 5929 6054 2 AOI22X1 $T=1167480 576840 0 180 $X=1164540 $Y=572395
X46477 VSS: 2 VSS: 6581 4681 6273 6276 3181 2 AOI22X2 $T=1176680 576840 1 0 $X=1176500 $Y=572395
X46487 VSS: 2 VSS: 6424 4096 6276 6273 4338 2 AOI22X2 $T=1175300 576840 0 0 $X=1175120 $Y=576575
X46494 VSS: 2 VSS: 6425 6427 6271 6279 6069 2 AOI22X1_HS $T=1171620 585120 0 180 $X=1168220 $Y=580675
X46497 VSS: 2 VSS: 6426 2595 2596 6279 6271 2 AOI22X1_HS $T=1178980 585120 0 180 $X=1175580 $Y=580675
X46512 VSS: 2 VSS: 6584 4267 2317 2319 6068 2 AOI22X1 $T=1178060 593400 1 0 $X=1177880 $Y=588955
X46518 VSS: 2 VSS: 6430 6069 6429 6181 6427 2 AOI22X2_HS $T=1165640 593400 0 0 $X=1165460 $Y=593135
X46533 VSS: 2 VSS: 6433 6429 3183 2808 6278 2 AOI22X1 $T=1169780 601680 0 0 $X=1169600 $Y=601415
X46549 VSS: 2 VSS: 6432 6073 4768 2 NAND2X2 $T=1166100 609960 0 0 $X=1165920 $Y=609695
X46559 VSS: 2 VSS: 6434 4096 6278 6175 4338 2 AOI22X2 $T=1170700 618240 1 0 $X=1170520 $Y=613795
X46570 VSS: 2 VSS: 6183 4617 6068 6275 4971 2 AOI22X2_HS $T=1173000 618240 0 0 $X=1172820 $Y=617975
X46601 VSS: 2 VSS: 6436 5199 2 CLKINVX4 $T=1174840 634800 0 0 $X=1174660 $Y=634535
X46622 VSS: 2 VSS: 6595 3870 5809 6594 4839 2 AOI22X2_HS $T=1201060 13800 0 180 $X=1195360 $Y=9355
X46623 VSS: 2 VSS: 5945 6440 6439 2 NAND2X2_HS $T=1183120 13800 1 180 $X=1179720 $Y=13535
X46628 VSS: 2 VSS: 6596 6077 6288 6595 2 NAND3X2_HS $T=1196000 13800 0 0 $X=1195820 $Y=13535
X46633 VSS: 2 VSS: 6196 6598 6594 5809 6597 2 AOI22X2_HS $T=1194620 22080 1 0 $X=1194440 $Y=17635
X46636 VSS: 2 VSS: 6440 6437 6195 2 NOR2X2_HS $T=1184500 22080 1 180 $X=1181100 $Y=21815
X46643 VSS: 2 VSS: 6441 8125 4463 6226 2 DFFX1_HS $T=1187260 30360 1 0 $X=1187080 $Y=25915
X46648 VSS: 2 VSS: 6083 3870 5808 6599 4839 2 AOI22X2_HS $T=1201060 30360 1 180 $X=1195360 $Y=30095
X46649 VSS: 2 VSS: 6446 6444 5946 6445 5806 2 NAND4X1 $T=1182660 38640 0 180 $X=1179720 $Y=34195
X46653 VSS: 2 VSS: 6443 3867 2 CLKBUFX4 $T=1193700 38640 1 0 $X=1193520 $Y=34195
X46655 VSS: 2 VSS: 6448 6082 6447 2 NOR2X2_HS $T=1180360 38640 0 0 $X=1180180 $Y=38375
X46660 VSS: 2 VSS: 6294 5809 2317 2343 6442 2 AOI22X1 $T=1193240 38640 0 0 $X=1193060 $Y=38375
X46662 VSS: 2 VSS: 6292 6450 6448 2 NAND2X2_HS $T=1184500 46920 0 180 $X=1181100 $Y=42475
X46666 VSS: 2 VSS: 6450 6451 5481 2 NOR2X2_HS $T=1192780 46920 0 180 $X=1189380 $Y=42475
X46676 VSS: 2 VSS: 6452 6296 6446 6297 2 NOR3X1 $T=1186800 55200 1 0 $X=1186620 $Y=50755
X46683 VSS: 2 VSS: 6453 6454 6299 6090 6302 2 NAND4X1 $T=1193700 55200 0 0 $X=1193520 $Y=54935
X46695 VSS: 2 VSS: 6457 8126 4396 6226 2 DFFX1_HS $T=1181280 71760 1 0 $X=1181100 $Y=67315
X46700 VSS: 2 VSS: 6458 5954 2317 2319 6457 2 AOI22X1 $T=1187720 71760 0 0 $X=1187540 $Y=71495
X46705 VSS: 2 VSS: 6460 5984 6459 6457 5275 2 AOI22X2_HS $T=1187260 80040 1 0 $X=1187080 $Y=75595
X46710 VSS: 2 VSS: 6462 6461 2013 2012 6459 2 AOI22X1 $T=1192780 80040 0 0 $X=1192600 $Y=79775
X46714 VSS: 2 VSS: 6464 6458 5488 6305 6463 2 NAND4X1 $T=1181740 88320 1 0 $X=1181560 $Y=83875
X46719 VSS: 2 VSS: 6607 8127 4463 5862 2 DFFX1_HS $T=1194620 88320 1 0 $X=1194440 $Y=83875
X46723 VSS: 2 VSS: 6465 6462 5957 6466 5959 2 NAND4X1 $T=1188180 88320 1 180 $X=1185240 $Y=88055
X46727 VSS: 2 VSS: 6601 7382 4461 5862 2 DFFX4_HS $T=1194620 88320 0 0 $X=1194440 $Y=88055
X46730 VSS: 2 VSS: 6467 6464 6465 6307 2 NOR3X1 $T=1184960 96600 1 0 $X=1184780 $Y=92155
X46734 VSS: 2 VSS: 6459 8128 4396 5862 2 DFFX1_HS $T=1193240 96600 1 0 $X=1193060 $Y=92155
X46737 VSS: 2 VSS: 6468 4660 6457 6459 4929 2 AOI22X2_HS $T=1191860 96600 1 180 $X=1186160 $Y=96335
X46741 VSS: 2 VSS: 6463 5684 2320 2558 6469 2 AOI22X1 $T=1184500 104880 0 180 $X=1181560 $Y=100435
X46746 VSS: 2 VSS: 6470 7383 4530 6226 2 DFFX4_HS $T=1180820 104880 0 0 $X=1180640 $Y=104615
X46752 VSS: 2 VSS: 6314 5956 2317 2319 6470 2 AOI22X1 $T=1190020 113160 1 0 $X=1189840 $Y=108715
X46760 VSS: 2 VSS: 6471 7384 4530 5862 2 DFFX4_HS $T=1185880 121440 1 0 $X=1185700 $Y=116995
X46767 VSS: 2 VSS: 6315 5695 2320 2558 6472 2 AOI22X1 $T=1184500 129720 0 180 $X=1181560 $Y=125275
X46780 VSS: 2 VSS: 6474 6477 2013 2012 6471 2 AOI22X1 $T=1193240 138000 1 0 $X=1193060 $Y=133555
X46786 VSS: 2 VSS: 6115 6478 6476 6479 6618 2 NAND4X2_HS $T=1192320 138000 0 0 $X=1192140 $Y=137735
X46790 VSS: 2 VSS: 6116 6481 6473 6480 6620 2 NAND4X4_HS $T=1189560 146280 1 0 $X=1189380 $Y=141835
X46800 VSS: 2 VSS: 6620 5817 6313 6477 3721 2 AOI22X1_HS $T=1195540 154560 1 0 $X=1195360 $Y=150115
X46802 VSS: 2 VSS: 6325 8129 4331 6226 2 DFFX1_HS $T=1183580 154560 0 0 $X=1183400 $Y=154295
X46804 VSS: 2 VSS: 6486 8130 4331 5862 2 DFFX1_HS $T=1193700 154560 0 0 $X=1193520 $Y=154295
X46816 VSS: 2 VSS: 6328 5701 2320 2558 6483 2 AOI22X1 $T=1185420 171120 0 180 $X=1182480 $Y=166675
X46826 VSS: 2 VSS: 6334 6487 5977 6485 5982 2 NAND4X1 $T=1187720 179400 0 180 $X=1184780 $Y=174955
X46829 VSS: 2 VSS: 6487 6484 2013 2012 6486 2 AOI22X1 $T=1193240 179400 1 0 $X=1193060 $Y=174955
X46850 VSS: 2 VSS: 6491 6489 6129 6130 6338 2 AOI22X2_HS $T=1185880 195960 1 180 $X=1180180 $Y=195695
X46855 VSS: 2 VSS: 6492 6130 6129 2596 2595 2 AOI22X2 $T=1183580 204240 1 0 $X=1183400 $Y=199795
X46863 VSS: 2 VSS: 6494 5821 5983 6493 3840 2 AOI22X1 $T=1186800 204240 0 0 $X=1186620 $Y=203975
X46870 VSS: 2 VSS: 6495 6340 6342 6491 6496 2 NAND4X2_HS $T=1190940 212520 1 0 $X=1190760 $Y=208075
X46876 VSS: 2 VSS: 6496 5707 5983 6493 6497 2 AOI22X2_HS $T=1190940 212520 0 0 $X=1190760 $Y=212255
X46878 VSS: 2 VSS: 6498 5980 2 BUFX8_HS $T=1180820 220800 1 0 $X=1180640 $Y=216355
X46881 VSS: 2 VSS: 6497 6498 2 INVX8_HS $T=1189100 220800 1 0 $X=1188920 $Y=216355
X46887 VSS: 2 VSS: 6500 6493 2320 2558 6499 2 AOI22X1 $T=1195080 220800 1 180 $X=1192140 $Y=220535
X46893 VSS: 2 VSS: 6503 6502 6490 6501 6500 2 NAND4X1 $T=1191860 229080 1 0 $X=1191680 $Y=224635
X46898 VSS: 2 VSS: 6501 6222 2555 2564 6347 2 AOI22X1 $T=1190480 229080 0 0 $X=1190300 $Y=228815
X46904 VSS: 2 VSS: 6639 6505 6506 6504 6640 2 NAND4X2_HS $T=1194620 237360 1 0 $X=1194440 $Y=232915
X46909 VSS: 2 VSS: 6505 3186 6349 6222 4790 2 AOI22X1 $T=1197380 237360 1 180 $X=1194440 $Y=237095
X46911 VSS: 2 VSS: 6506 4223 6223 6345 4094 2 AOI22X2 $T=1182660 245640 1 0 $X=1182480 $Y=241195
X46920 VSS: 2 VSS: 6643 5003 6349 6222 5208 2 AOI22X2_HS $T=1193700 245640 0 0 $X=1193520 $Y=245375
X46944 VSS: 2 VSS: 6508 7385 4920 6226 2 DFFX4_HS $T=1183120 270480 0 0 $X=1182940 $Y=270215
X46951 VSS: 2 VSS: 6650 6353 6228 5208 5003 2 AOI22X1 $T=1195080 278760 1 0 $X=1194900 $Y=274315
X46958 VSS: 2 VSS: 6509 5285 4877 6232 6229 2 AOI22X2_HS $T=1182200 287040 1 0 $X=1182020 $Y=282595
X46970 VSS: 2 VSS: 6511 4094 6230 6224 4223 2 AOI22X1 $T=1192320 295320 1 0 $X=1192140 $Y=290875
X46974 VSS: 2 VSS: 6512 3186 6353 6228 4790 2 AOI22X1 $T=1197840 295320 1 180 $X=1194900 $Y=295055
X46980 VSS: 2 VSS: 6656 6512 6510 6511 6657 2 NAND4X2_HS $T=1193240 303600 1 0 $X=1193060 $Y=299155
X46985 VSS: 2 VSS: 6513 6228 2555 2564 6356 2 AOI22X1 $T=1187720 303600 0 0 $X=1187540 $Y=303335
X46989 VSS: 2 VSS: 6514 7386 4536 6226 2 DFFX4_HS $T=1183580 311880 1 0 $X=1183400 $Y=307435
X46991 VSS: 2 VSS: 6659 7387 4536 5862 2 DFFX4_HS $T=1196000 311880 1 0 $X=1195820 $Y=307435
X47001 VSS: 2 VSS: 6517 6515 6364 6513 6516 2 NAND4X1 $T=1193240 320160 1 0 $X=1193060 $Y=315715
X47009 VSS: 2 VSS: 6519 6236 6363 2596 2595 2 AOI22X2 $T=1182200 328440 1 0 $X=1182020 $Y=323995
X47013 VSS: 2 VSS: 6667 7388 4504 6226 2 DFFX4_HS $T=1188180 328440 0 0 $X=1188000 $Y=328175
X47014 VSS: 2 VSS: 6521 5980 2 INVX16_HS $T=1180820 336720 1 0 $X=1180640 $Y=332275
X47016 VSS: 2 VSS: 6669 8131 5258 6226 2 DFFX1_HS $T=1190020 336720 1 0 $X=1189840 $Y=332275
X47023 VSS: 2 VSS: 6522 6520 6366 5707 6521 2 AOI22X1_HS $T=1187260 345000 1 0 $X=1187080 $Y=340555
X47028 VSS: 2 VSS: 6523 6489 6363 6236 6367 2 AOI22X2_HS $T=1183580 345000 0 0 $X=1183400 $Y=344735
X47033 VSS: 2 VSS: 6525 6368 6015 2 NAND2X1 $T=1195080 353280 1 0 $X=1194900 $Y=348835
X47037 VSS: 2 VSS: 6528 6525 6526 6527 6369 2 NAND4X1_HS $T=1191860 353280 1 180 $X=1188460 $Y=353015
X47042 VSS: 2 VSS: 6527 4669 6237 6371 6489 2 AOI22X1_HS $T=1187260 361560 0 180 $X=1183860 $Y=357115
X47047 VSS: 2 VSS: 6526 5707 6370 6524 6521 2 AOI22X1_HS $T=1185420 361560 0 0 $X=1185240 $Y=361295
X47051 VSS: 2 VSS: 6529 6237 6371 2596 2595 2 AOI22X2 $T=1179900 369840 1 0 $X=1179720 $Y=365395
X47058 VSS: 2 VSS: 6530 6371 3183 2808 6238 2 AOI22X1 $T=1181740 369840 0 0 $X=1181560 $Y=369575
X47067 VSS: 2 VSS: 6531 6378 2317 2319 6667 2 AOI22X1 $T=1197840 378120 0 180 $X=1194900 $Y=373675
X47073 VSS: 2 VSS: 6532 6375 2555 2564 6533 2 AOI22X1 $T=1194160 378120 0 0 $X=1193980 $Y=377855
X47078 VSS: 2 VSS: 6680 6534 6379 6535 6681 2 NAND4X2_HS $T=1193700 386400 1 0 $X=1193520 $Y=381955
X47083 VSS: 2 VSS: 6534 3186 6377 6375 4790 2 AOI22X1_HS $T=1191860 386400 0 0 $X=1191680 $Y=386135
X47087 VSS: 2 VSS: 6536 6377 6375 4133 3190 2 AOI22X1_HS $T=1194160 394680 0 180 $X=1190760 $Y=390235
X47092 VSS: 2 VSS: 6535 6255 6380 4094 4223 2 AOI22X1_HS $T=1191400 394680 0 0 $X=1191220 $Y=394415
X47097 VSS: 2 VSS: 6537 5145 6380 6255 5906 2 AOI22X1_HS $T=1196000 402960 0 180 $X=1192600 $Y=398515
X47110 VSS: 2 VSS: 6539 4094 6244 6256 4223 2 AOI22X1 $T=1188640 411240 1 180 $X=1185700 $Y=410975
X47117 VSS: 2 VSS: 6540 3785 6243 6383 4258 2 AOI22X1 $T=1187260 419520 1 0 $X=1187080 $Y=415075
X47123 VSS: 2 VSS: 6542 6540 6539 6543 6541 2 NAND4X2_HS $T=1186800 419520 0 0 $X=1186620 $Y=419255
X47126 VSS: 2 VSS: 6679 7389 4504 6029 2 DFFX4_HS $T=1195080 419520 0 0 $X=1194900 $Y=419255
X47130 VSS: 2 VSS: 6543 3186 4790 6246 6387 2 AOI22X1_HS $T=1192320 427800 0 180 $X=1188920 $Y=423355
X47135 VSS: 2 VSS: 6544 6387 6246 4133 3190 2 AOI22X1_HS $T=1184040 427800 0 0 $X=1183860 $Y=427535
X47142 VSS: 2 VSS: 6545 6246 2555 2564 6385 2 AOI22X1 $T=1192780 436080 1 0 $X=1192600 $Y=431635
X47145 VSS: 2 VSS: 6546 6248 3183 2808 6249 2 AOI22X1 $T=1181740 436080 0 0 $X=1181560 $Y=435815
X47152 VSS: 2 VSS: 6549 6548 6388 5333 6521 2 AOI22X1_HS $T=1187260 444360 1 0 $X=1187080 $Y=439915
X47155 VSS: 2 VSS: 6700 6391 6547 6701 6699 2 NAND4X4_HS $T=1196000 444360 1 0 $X=1195820 $Y=439915
X47157 VSS: 2 VSS: 6547 6247 6248 2596 2595 2 AOI22X2 $T=1180820 444360 0 0 $X=1180640 $Y=444095
X47160 VSS: 2 VSS: 6550 6390 6549 2 AND2X1_HS $T=1192780 444360 0 0 $X=1192600 $Y=444095
X47166 VSS: 2 VSS: 6553 6550 6551 6552 2 NAND3X2_HS $T=1191400 452640 1 0 $X=1191220 $Y=448195
X47170 VSS: 2 VSS: 6548 8132 5258 6354 2 DFFX1_HS $T=1181280 452640 0 0 $X=1181100 $Y=452375
X47172 VSS: 2 VSS: 6552 6395 4768 2 NAND2X1 $T=1194160 452640 0 0 $X=1193980 $Y=452375
X47179 VSS: 2 VSS: 6554 6396 6556 6555 6397 2 NAND4X2_HS $T=1196460 460920 0 180 $X=1190760 $Y=456475
X47181 VSS: 2 VSS: 6556 6521 5333 6398 6557 2 AOI22X2 $T=1186340 460920 0 0 $X=1186160 $Y=460655
X47189 VSS: 2 VSS: 6558 6557 2320 2558 6559 2 AOI22X1 $T=1194160 469200 1 180 $X=1191220 $Y=468935
X47197 VSS: 2 VSS: 6561 2596 6254 6253 2595 2 AOI22X2 $T=1183580 477480 0 0 $X=1183400 $Y=477215
X47202 VSS: 2 VSS: 6563 6254 3183 2808 6252 2 AOI22X1 $T=1181280 485760 1 0 $X=1181100 $Y=481315
X47209 VSS: 2 VSS: 6564 6253 3028 3029 6401 2 AOI22X1 $T=1182660 485760 0 0 $X=1182480 $Y=485495
X47221 VSS: 2 VSS: 6706 6400 2317 2319 6059 2 AOI22X1 $T=1194620 494040 0 0 $X=1194440 $Y=493775
X47226 VSS: 2 VSS: 6565 6403 3190 4133 6259 2 AOI22X1 $T=1191400 502320 1 0 $X=1191220 $Y=497875
X47231 VSS: 2 VSS: 6562 6259 2555 2564 6567 2 AOI22X1 $T=1190020 502320 0 0 $X=1189840 $Y=502055
X47233 VSS: 2 VSS: 6566 5285 6263 6401 3453 2 AOI22X2_HS $T=1185420 510600 0 180 $X=1179720 $Y=506155
X47240 VSS: 2 VSS: 6568 4386 6259 6403 4045 2 AOI22X1_HS $T=1196920 510600 1 180 $X=1193520 $Y=510335
X47245 VSS: 2 VSS: 6716 6568 6569 2 AND2X1_HS $T=1194620 518880 1 0 $X=1194440 $Y=514435
X47248 VSS: 2 VSS: 6569 4094 6261 6260 4223 2 AOI22X2_HS $T=1194160 518880 1 180 $X=1188460 $Y=518615
X47257 VSS: 2 VSS: 6570 5145 6262 6267 5906 2 AOI22X1_HS $T=1196000 527160 1 180 $X=1192600 $Y=526895
X47269 VSS: 2 VSS: 6571 6406 6405 4133 3190 2 AOI22X1 $T=1192780 535440 0 0 $X=1192600 $Y=535175
X47274 VSS: 2 VSS: 6575 4094 6262 6267 4223 2 AOI22X1_HS $T=1194620 543720 1 0 $X=1194440 $Y=539275
X47279 VSS: 2 VSS: 6573 4790 6405 6406 4045 2 AOI22X1 $T=1196460 543720 1 180 $X=1193520 $Y=543455
X47283 VSS: 2 VSS: 6574 4258 6257 6265 3785 2 AOI22X2 $T=1189560 552000 1 0 $X=1189380 $Y=547555
X47290 VSS: 2 VSS: 6718 6573 6574 6575 6710 2 NAND4X2_HS $T=1194620 552000 0 0 $X=1194440 $Y=551735
X47296 VSS: 2 VSS: 6576 6402 2317 2319 6064 2 AOI22X1 $T=1193700 560280 1 0 $X=1193520 $Y=555835
X47301 VSS: 2 VSS: 6577 6405 2555 2564 6415 2 AOI22X1 $T=1191860 560280 0 0 $X=1191680 $Y=560015
X47303 VSS: 2 VSS: 6580 6065 6419 5333 6521 2 AOI22X1_HS $T=1180360 568560 1 0 $X=1180180 $Y=564115
X47308 VSS: 2 VSS: 6578 6576 6422 6577 6579 2 NAND4X1 $T=1193240 568560 0 180 $X=1190300 $Y=564115
X47315 VSS: 2 VSS: 6583 3840 6065 6419 5821 2 AOI22X2 $T=1193240 568560 0 0 $X=1193060 $Y=568295
X47319 VSS: 2 VSS: 6724 6581 6580 6425 6582 2 NAND4X2_HS $T=1197840 576840 0 180 $X=1192140 $Y=572395
X47322 VSS: 2 VSS: 6582 6072 6015 2 NAND2X2 $T=1187260 576840 0 0 $X=1187080 $Y=576575
X47325 VSS: 2 VSS: 6726 6424 6583 6426 6727 2 NAND4X2_HS $T=1192320 576840 0 0 $X=1192140 $Y=576575
X47329 VSS: 2 VSS: 6427 5390 2 BUFX8_HS $T=1190480 585120 1 0 $X=1190300 $Y=580675
X47335 VSS: 2 VSS: 6729 6728 6428 6423 2 NAND3X2_HS $T=1194160 585120 0 0 $X=1193980 $Y=584855
X47342 VSS: 2 VSS: 6585 6729 2 INVX2_HS $T=1197380 593400 0 180 $X=1194900 $Y=588955
X47348 VSS: 2 VSS: 6431 6521 5333 6421 6070 2 AOI22X2 $T=1186800 601680 0 180 $X=1182020 $Y=597235
X47356 VSS: 2 VSS: 6587 6281 6585 2 NAND2X4_HS $T=1191400 601680 0 0 $X=1191220 $Y=601415
X47359 VSS: 2 VSS: 6589 6584 6433 6588 6586 2 NAND4X1 $T=1184960 609960 0 180 $X=1182020 $Y=605515
X47364 VSS: 2 VSS: 6057 6589 6283 6590 2 NOR3X1 $T=1183580 609960 1 180 $X=1181100 $Y=609695
X47374 VSS: 2 VSS: 6734 6073 1701 1726 6169 2 AOI22X1 $T=1196000 618240 1 0 $X=1195820 $Y=613795
X47381 VSS: 2 VSS: 6588 4232 2555 2564 6572 2 AOI22X1 $T=1185420 626520 1 0 $X=1185240 $Y=622075
X47388 VSS: 2 VSS: 6591 5939 6421 6070 1683 2 AOI22X1_HS $T=1192320 626520 0 0 $X=1192140 $Y=626255
X47392 VSS: 2 VSS: 6592 6434 6435 6591 6593 2 NAND4X4_HS $T=1190020 634800 1 0 $X=1189840 $Y=630355
X47396 VSS: 2 VSS: 6593 6073 6436 2 NAND2X4 $T=1194160 634800 1 180 $X=1189840 $Y=634535
X47401 VSS: 2 VSS: 5197 6587 6592 2 NOR2X4_HS $T=1196920 643080 0 180 $X=1191680 $Y=638635
X47422 VSS: 2 VSS: 6192 6598 6599 5808 6597 2 AOI22X2 $T=1199680 22080 0 0 $X=1199500 $Y=21815
X47428 VSS: 2 VSS: 6600 7390 4461 6290 2 DFFX4_HS $T=1199220 30360 1 0 $X=1199040 $Y=25915
X47438 VSS: 2 VSS: 6742 8133 4463 6290 2 DFFX1_HS $T=1211640 30360 0 0 $X=1211460 $Y=30095
X47443 VSS: 2 VSS: 6444 6600 2013 2012 6601 2 AOI22X1 $T=1207960 38640 1 0 $X=1207780 $Y=34195
X47452 VSS: 2 VSS: 6745 6742 2013 2012 6607 2 AOI22X1 $T=1212560 38640 0 0 $X=1212380 $Y=38375
X47456 VSS: 2 VSS: 2319 2343 2 CLKBUFX4 $T=1202440 46920 0 180 $X=1199500 $Y=42475
X47465 VSS: 2 VSS: 6293 5808 2317 2319 6441 2 AOI22X1 $T=1197380 46920 0 0 $X=1197200 $Y=46655
X47471 VSS: 2 VSS: 6598 5282 2 BUFX4_HS $T=1198300 55200 1 0 $X=1198120 $Y=50755
X47482 VSS: 2 VSS: 6597 5038 2 CLKBUFX2_HS $T=1208420 55200 1 180 $X=1205020 $Y=54935
X47486 VSS: 2 VSS: 6093 6597 5954 6602 6598 2 AOI22X1_HS $T=1198300 63480 1 0 $X=1198120 $Y=59035
X47494 VSS: 2 VSS: 6101 3870 4839 6602 5954 2 AOI22X2_HS $T=1202440 63480 1 180 $X=1196740 $Y=63215
X47499 VSS: 2 VSS: 6603 3790 6461 6303 3810 2 AOI22X2_HS $T=1205200 71760 0 180 $X=1199500 $Y=67315
X47502 VSS: 2 VSS: 6461 7391 4396 6290 2 DFFX4_HS $T=1209340 71760 1 0 $X=1209160 $Y=67315
X47509 VSS: 2 VSS: 6604 5817 6303 6461 3721 2 AOI22X2_HS $T=1209340 71760 1 180 $X=1203640 $Y=71495
X47515 VSS: 2 VSS: 6757 5331 6455 6750 5130 2 AOI22X2_HS $T=1216700 80040 0 180 $X=1211000 $Y=75595
X47523 VSS: 2 VSS: 6102 6605 6606 6460 6604 2 NAND4X4_HS $T=1206120 80040 0 0 $X=1205940 $Y=79775
X47526 VSS: 2 VSS: 6456 7392 4461 6608 2 DFFX4_HS $T=1205200 88320 1 0 $X=1205020 $Y=83875
X47532 VSS: 2 VSS: 6455 8134 4463 6608 2 DFFX1_HS $T=1206580 88320 0 0 $X=1206400 $Y=88055
X47534 VSS: 2 VSS: 6469 7393 4396 6608 2 DFFX4_HS $T=1202900 96600 1 0 $X=1202720 $Y=92155
X47540 VSS: 2 VSS: 6104 6603 6610 6468 6609 2 NAND4X2_HS $T=1203360 96600 0 0 $X=1203180 $Y=96335
X47544 VSS: 2 VSS: 6610 4175 6611 6304 6612 2 AOI22X2_HS $T=1199680 104880 1 0 $X=1199500 $Y=100435
X47551 VSS: 2 VSS: 6605 5814 6611 6304 5813 2 AOI22X2 $T=1199680 104880 0 0 $X=1199500 $Y=104615
X47556 VSS: 2 VSS: 6611 7394 4396 5914 2 DFFX4_HS $T=1211180 104880 0 0 $X=1211000 $Y=104615
X47561 VSS: 2 VSS: 6606 6613 6614 6615 4367 2 AOI22X2 $T=1213020 113160 0 180 $X=1208240 $Y=108715
X47566 VSS: 2 VSS: 6480 5984 6471 6470 5275 2 AOI22X2_HS $T=1196920 113160 0 0 $X=1196740 $Y=112895
X47572 VSS: 2 VSS: 6609 4927 6615 6614 6616 2 AOI22X2_HS $T=1210260 121440 0 180 $X=1204560 $Y=116995
X47577 VSS: 2 VSS: 6476 6471 6470 4660 4929 2 AOI22X2_HS $T=1196920 121440 0 0 $X=1196740 $Y=121175
X47582 VSS: 2 VSS: 6473 5814 6617 6311 6443 2 AOI22X2_HS $T=1197840 129720 1 0 $X=1197660 $Y=125275
X47587 VSS: 2 VSS: 6472 7395 4530 6608 2 DFFX4_HS $T=1210260 129720 1 0 $X=1210080 $Y=125275
X47593 VSS: 2 VSS: 6618 4175 6617 6311 6612 2 AOI22X2_HS $T=1197840 129720 0 0 $X=1197660 $Y=129455
X47597 VSS: 2 VSS: 6617 7396 4530 5914 2 DFFX4_HS $T=1208420 129720 0 0 $X=1208240 $Y=129455
X47609 VSS: 2 VSS: 6479 4374 6619 6775 4927 2 AOI22X2 $T=1213480 138000 1 180 $X=1208700 $Y=137735
X47614 VSS: 2 VSS: 6481 4367 6775 6619 6613 2 AOI22X2_HS $T=1208420 146280 1 0 $X=1208240 $Y=141835
X47618 VSS: 2 VSS: 6478 3790 6477 6313 3810 2 AOI22X2_HS $T=1197380 146280 0 0 $X=1197200 $Y=146015
X47623 VSS: 2 VSS: 6608 5129 2 CLKBUFX8 $T=1209800 146280 0 0 $X=1209620 $Y=146015
X47629 VSS: 2 VSS: 6614 7397 4396 5860 2 DFFX4_HS $T=1209340 154560 1 0 $X=1209160 $Y=150115
X47633 VSS: 2 VSS: 6477 7398 4530 6290 2 DFFX4_HS $T=1202900 154560 0 0 $X=1202720 $Y=154295
X47635 VSS: 2 VSS: 6621 6486 6325 5275 5984 2 AOI22X1_HS $T=1197840 162840 1 0 $X=1197660 $Y=158395
X47640 VSS: 2 VSS: 6619 7399 4530 5860 2 DFFX4_HS $T=1212560 162840 1 0 $X=1212380 $Y=158395
X47646 VSS: 2 VSS: 6613 4733 2 BUFX16_HS $T=1207960 162840 1 180 $X=1197660 $Y=162575
X47652 VSS: 2 VSS: 5978 6622 6623 6621 6625 2 NAND4X2_HS $T=1197840 171120 1 0 $X=1197660 $Y=166675
X47655 VSS: 2 VSS: 6622 6613 6624 6780 4367 2 AOI22X2 $T=1215320 171120 0 180 $X=1210540 $Y=166675
X47660 VSS: 2 VSS: 6623 5817 6331 6484 3721 2 AOI22X1 $T=1199220 171120 0 0 $X=1199040 $Y=170855
X47665 VSS: 2 VSS: 6483 8135 4331 6608 2 DFFX1_HS $T=1212100 171120 0 0 $X=1211920 $Y=170855
X47669 VSS: 2 VSS: 6625 6626 6336 6443 5814 2 AOI22X1_HS $T=1204740 179400 1 0 $X=1204560 $Y=174955
X47675 VSS: 2 VSS: 6627 4971 6486 6325 4660 2 AOI22X2_HS $T=1202440 179400 1 180 $X=1196740 $Y=179135
X47679 VSS: 2 VSS: 6628 4175 6626 6336 5846 2 AOI22X2_HS $T=1197380 187680 1 0 $X=1197200 $Y=183235
X47683 VSS: 2 VSS: 6626 8136 4331 5914 2 DFFX1_HS $T=1212100 187680 1 0 $X=1211920 $Y=183235
X47688 VSS: 2 VSS: 6218 6629 6627 6630 6628 2 NAND4X2_HS $T=1202900 187680 1 180 $X=1197200 $Y=187415
X47692 VSS: 2 VSS: 6629 4374 6624 6780 4927 2 AOI22X2 $T=1216700 187680 1 180 $X=1211920 $Y=187415
X47693 VSS: 2 VSS: 6630 3790 6484 6331 6631 2 AOI22X2_HS $T=1197840 195960 1 0 $X=1197660 $Y=191515
X47704 VSS: 2 VSS: 6484 8137 4331 6290 2 DFFX1_HS $T=1203820 195960 0 0 $X=1203640 $Y=195695
X47707 VSS: 2 VSS: 6612 3859 2 BUFX8_HS $T=1209340 204240 0 180 $X=1203640 $Y=199795
X47715 VSS: 2 VSS: 6633 6632 6494 6492 6341 2 NAND4X2_HS $T=1211640 204240 1 180 $X=1205940 $Y=203975
X47723 VSS: 2 VSS: 6632 6343 3843 2 NAND2X1_HS $T=1207040 212520 1 0 $X=1206860 $Y=208075
X47731 VSS: 2 VSS: 2675 6634 2 BUFX16_HS $T=1213020 212520 1 180 $X=1202720 $Y=212255
X47734 VSS: 2 VSS: 6636 6344 1991 1990 5983 2 AOI22X1 $T=1202440 220800 1 0 $X=1202260 $Y=216355
X47746 VSS: 2 VSS: 6499 7400 4920 6608 2 DFFX4_HS $T=1209340 220800 0 0 $X=1209160 $Y=220535
X47751 VSS: 2 VSS: 6794 6638 6636 6346 6637 2 NAND4X1 $T=1210260 229080 1 0 $X=1210080 $Y=224635
X47758 VSS: 2 VSS: 6637 6343 1701 1726 6482 2 AOI22X1 $T=1207960 229080 0 0 $X=1207780 $Y=228815
X47772 VSS: 2 VSS: 6797 6503 6641 6794 2 NOR3X1 $T=1212560 237360 0 0 $X=1212380 $Y=237095
X47777 VSS: 2 VSS: 6641 6642 6348 6798 6350 2 NAND4X1 $T=1213020 245640 0 180 $X=1210080 $Y=241195
X47788 VSS: 2 VSS: 6646 6643 6644 2 AND2X1_HS $T=1201520 253920 1 0 $X=1201340 $Y=249475
X47798 VSS: 2 VSS: 6645 6646 6507 6351 2 NAND3X2_HS $T=1201980 253920 0 0 $X=1201800 $Y=253655
X47805 VSS: 2 VSS: 6644 5038 6362 6647 5282 2 AOI22X1_HS $T=1209340 262200 1 0 $X=1209160 $Y=257755
X47812 VSS: 2 VSS: 6648 5137 2 CLKBUFX8 $T=1201980 262200 0 0 $X=1201800 $Y=261935
X47815 VSS: 2 VSS: 6640 3580 6362 6647 4839 2 AOI22X2_HS $T=1213940 262200 1 180 $X=1208240 $Y=261935
X47816 VSS: 2 VSS: 6502 6362 2317 2343 6508 2 AOI22X1 $T=1196460 270480 1 0 $X=1196280 $Y=266035
X47825 VSS: 2 VSS: 6649 7401 4920 5862 2 DFFX4_HS $T=1198760 270480 0 0 $X=1198580 $Y=270215
X47838 VSS: 2 VSS: 6652 6651 6509 6650 6352 2 NAND4X2_HS $T=1205660 278760 1 180 $X=1199960 $Y=278495
X47853 VSS: 2 VSS: 2890 6653 2 BUFX16_HS $T=1206580 287040 0 0 $X=1206400 $Y=286775
X47859 VSS: 2 VSS: 6655 6654 6806 2 NOR2X2_HS $T=1212100 295320 1 0 $X=1211920 $Y=290875
X47868 VSS: 2 VSS: 6653 6808 6655 2 NAND2X2_HS $T=1213480 295320 1 180 $X=1210080 $Y=295055
X47874 VSS: 2 VSS: 6808 6809 6656 2 NOR2X2_HS $T=1215780 303600 0 180 $X=1212380 $Y=299155
X47883 VSS: 2 VSS: 6651 5282 6658 6365 5038 2 AOI22X1 $T=1211180 303600 1 180 $X=1208240 $Y=303335
X47888 VSS: 2 VSS: 6657 3580 6365 6658 4839 2 AOI22X2 $T=1217160 311880 0 180 $X=1212380 $Y=307435
X47893 VSS: 2 VSS: 6515 6365 2317 2319 6514 2 AOI22X1 $T=1197380 311880 0 0 $X=1197200 $Y=311615
X47900 VSS: 2 VSS: 6660 6661 6663 6355 6662 2 NAND4X1 $T=1207040 320160 1 0 $X=1206860 $Y=315715
X47906 VSS: 2 VSS: 6654 6664 6519 6665 6518 2 NAND4X2_HS $T=1206120 320160 1 180 $X=1200420 $Y=319895
X47913 VSS: 2 VSS: 6662 6361 1701 1726 6225 2 AOI22X1 $T=1206580 328440 1 0 $X=1206400 $Y=323995
X47920 VSS: 2 VSS: 6516 6520 2320 2558 6666 2 AOI22X1 $T=1203360 328440 1 180 $X=1200420 $Y=328175
X47925 VSS: 2 VSS: 6664 6361 3843 2 NAND2X1 $T=1210260 328440 0 0 $X=1210080 $Y=328175
X47931 VSS: 2 VSS: 6663 6668 1991 1990 6366 2 AOI22X1 $T=1207960 336720 1 0 $X=1207780 $Y=332275
X47937 VSS: 2 VSS: 6665 3840 6520 6366 5821 2 AOI22X2 $T=1206120 336720 1 180 $X=1201340 $Y=336455
X47943 VSS: 2 VSS: 6670 6360 6523 6522 6671 2 NAND4X2_HS $T=1209340 345000 0 180 $X=1203640 $Y=340555
X47954 VSS: 2 VSS: 6672 6368 1701 1726 6227 2 AOI22X1 $T=1213480 345000 1 180 $X=1210540 $Y=344735
X47958 VSS: 2 VSS: 6671 6361 6015 2 NAND2X1 $T=1205200 353280 0 180 $X=1203180 $Y=348835
X47962 VSS: 2 VSS: 6822 6368 3843 2 NAND2X1 $T=1211640 353280 1 0 $X=1211460 $Y=348835
X47968 VSS: 2 VSS: 6674 6524 2320 2558 6673 2 AOI22X1 $T=1206120 353280 1 180 $X=1203180 $Y=353015
X47974 VSS: 2 VSS: 6673 7402 4504 6608 2 DFFX4_HS $T=1206120 361560 1 0 $X=1205940 $Y=357115
X47980 VSS: 2 VSS: 6675 3840 6524 6370 5821 2 AOI22X2 $T=1202440 361560 0 0 $X=1202260 $Y=361295
X47988 VSS: 2 VSS: 6825 6822 6372 6675 6529 2 NAND4X2_HS $T=1215320 369840 0 180 $X=1209620 $Y=365395
X47994 VSS: 2 VSS: 6676 6531 6530 6532 6674 2 NAND4X1 $T=1201060 369840 0 0 $X=1200880 $Y=369575
X48002 VSS: 2 VSS: 6829 6677 6678 6373 6672 2 NAND4X1 $T=1210720 378120 1 0 $X=1210540 $Y=373675
X48010 VSS: 2 VSS: 6678 6679 1991 1990 6370 2 AOI22X1 $T=1209800 378120 0 0 $X=1209620 $Y=377855
X48024 VSS: 2 VSS: 6681 4839 6682 6378 3580 2 AOI22X1_HS $T=1215320 386400 1 180 $X=1211920 $Y=386135
X48029 VSS: 2 VSS: 6683 5282 6682 6378 5038 2 AOI22X1_HS $T=1207500 394680 1 0 $X=1207320 $Y=390235
X48037 VSS: 2 VSS: 6684 6683 6536 2 AND2X1_HS $T=1206580 394680 0 0 $X=1206400 $Y=394415
X48041 VSS: 2 VSS: 6685 6684 6537 6381 2 NAND3X2_HS $T=1205200 402960 1 0 $X=1205020 $Y=398515
X48047 VSS: 2 VSS: 6686 5145 6244 6256 5906 2 AOI22X1_HS $T=1197380 402960 0 0 $X=1197200 $Y=402695
X48054 VSS: 2 VSS: 6687 6688 6538 6686 2 NAND3X2_HS $T=1200140 411240 1 0 $X=1199960 $Y=406795
X48062 VSS: 2 VSS: 6688 6689 6544 2 AND2X1_HS $T=1200600 411240 0 0 $X=1200420 $Y=410975
X48066 VSS: 2 VSS: 6689 5282 6690 6384 5038 2 AOI22X1_HS $T=1212560 411240 1 180 $X=1209160 $Y=410975
X48069 VSS: 2 VSS: 6691 6384 2317 2343 6669 2 AOI22X1 $T=1198300 419520 1 0 $X=1198120 $Y=415075
X48073 VSS: 2 VSS: 6541 3580 6384 6690 4839 2 AOI22X2 $T=1213480 419520 0 180 $X=1208700 $Y=415075
X48077 VSS: 2 VSS: 6668 7403 4536 6029 2 DFFX4_HS $T=1206580 419520 0 0 $X=1206400 $Y=419255
X48081 VSS: 2 VSS: 6692 8138 5258 6029 2 DFFX1_HS $T=1205660 427800 1 0 $X=1205480 $Y=423355
X48089 VSS: 2 VSS: 6693 6692 1991 1990 6388 2 AOI22X1 $T=1207960 427800 1 180 $X=1205020 $Y=427535
X48096 VSS: 2 VSS: 6696 6695 6693 6245 6694 2 NAND4X1 $T=1209340 436080 1 0 $X=1209160 $Y=431635
X48102 VSS: 2 VSS: 6697 6691 6546 6545 6698 2 NAND4X1 $T=1201060 436080 0 0 $X=1200880 $Y=435815
X48110 VSS: 2 VSS: 6701 3840 6548 6388 5821 2 AOI22X2 $T=1211640 444360 1 0 $X=1211460 $Y=439915
X48116 VSS: 2 VSS: 6698 6548 2320 2558 6702 2 AOI22X1 $T=1204740 444360 1 180 $X=1201800 $Y=444095
X48120 VSS: 2 VSS: 6702 8139 5258 6608 2 DFFX1_HS $T=1209800 444360 0 0 $X=1209620 $Y=444095
X48125 VSS: 2 VSS: 6694 6395 1701 1726 6264 2 AOI22X1 $T=1210720 452640 0 180 $X=1207780 $Y=448195
X48132 VSS: 2 VSS: 6699 6395 3843 2 NAND2X2 $T=1204740 452640 1 180 $X=1202260 $Y=452375
X48146 VSS: 2 VSS: 6559 7404 4880 6608 2 DFFX4_HS $T=1203820 460920 0 0 $X=1203640 $Y=460655
X48148 VSS: 2 VSS: 6555 6399 4768 2 NAND2X2_HS $T=1198300 469200 1 0 $X=1198120 $Y=464755
X48151 VSS: 2 VSS: 6703 6399 3843 2 NAND2X4 $T=1213020 469200 0 180 $X=1208700 $Y=464755
X48158 VSS: 2 VSS: 6856 6561 6560 6703 6852 2 NAND4X2_HS $T=1208880 469200 0 0 $X=1208700 $Y=468935
X48163 VSS: 2 VSS: 6704 5038 6400 6857 5282 2 AOI22X2 $T=1214400 477480 0 180 $X=1209620 $Y=473035
X48170 VSS: 2 VSS: 6705 5038 6402 6709 5282 2 AOI22X2 $T=1213020 477480 1 180 $X=1208240 $Y=477215
X48172 VSS: 2 VSS: 6707 6706 6563 6562 6558 2 NAND4X1 $T=1199220 485760 1 0 $X=1199040 $Y=481315
X48183 VSS: 2 VSS: 6708 3580 4839 6857 6400 2 AOI22X2_HS $T=1213480 485760 1 180 $X=1207780 $Y=485495
X48187 VSS: 2 VSS: 6710 4839 6709 6402 3580 2 AOI22X1_HS $T=1202440 494040 0 180 $X=1199040 $Y=489595
X48202 VSS: 2 VSS: 6713 6707 6712 6711 2 NOR3X1 $T=1208880 502320 1 0 $X=1208700 $Y=497875
X48211 VSS: 2 VSS: 6715 6565 6566 6704 6714 2 NAND4X2_HS $T=1213480 502320 1 180 $X=1207780 $Y=502055
X48218 VSS: 2 VSS: 6865 6399 1701 1726 6268 2 AOI22X1 $T=1210720 510600 1 0 $X=1210540 $Y=506155
X48226 VSS: 2 VSS: 6866 6408 6716 6708 2 NAND3X4_HS $T=1209800 510600 0 0 $X=1209620 $Y=510335
X48241 VSS: 2 VSS: 6714 5906 6260 6261 5145 2 AOI22X2_HS $T=1197380 527160 1 0 $X=1197200 $Y=522715
X48255 VSS: 2 VSS: 6717 6571 6705 6413 6570 2 NAND4X2_HS $T=1204740 535440 0 180 $X=1199040 $Y=530995
X48265 VSS: 2 VSS: 5357 7405 2945 5914 2 DFFX4_HS $T=1207500 535440 0 0 $X=1207320 $Y=535175
X48268 VSS: 2 VSS: 6871 7406 4880 6029 2 DFFX4_HS $T=1205200 543720 1 0 $X=1205020 $Y=539275
X48276 VSS: 2 VSS: 5649 7407 2945 6608 2 DFFX4_HS $T=1203360 543720 0 0 $X=1203180 $Y=543455
X48280 VSS: 2 VSS: 6731 7408 3904 6029 2 DFFX4_HS $T=1206120 552000 1 0 $X=1205940 $Y=547555
X48292 VSS: 2 VSS: 6876 7409 4883 6029 2 DFFX4_HS $T=1205200 560280 1 0 $X=1205020 $Y=555835
X48299 VSS: 2 VSS: 2708 6719 2 BUFX16_HS $T=1203360 560280 0 0 $X=1203180 $Y=560015
X48303 VSS: 2 VSS: 6579 6065 2320 2558 6720 2 AOI22X1 $T=1202900 568560 0 180 $X=1199960 $Y=564115
X48307 VSS: 2 VSS: 6719 6721 6722 2 NAND2X2_HS $T=1209340 568560 0 180 $X=1205940 $Y=564115
X48310 VSS: 2 VSS: 6721 6717 6880 2 NOR2X2_HS $T=1210720 568560 1 0 $X=1210540 $Y=564115
X48318 VSS: 2 VSS: 6722 6723 6724 2 NOR2X2_HS $T=1206120 568560 1 180 $X=1202720 $Y=568295
X48331 VSS: 2 VSS: 6727 6072 3843 2 NAND2X1_HS $T=1202440 576840 1 180 $X=1199960 $Y=576575
X48334 VSS: 2 VSS: 6725 6072 1701 1726 6270 2 AOI22X1 $T=1209800 576840 0 0 $X=1209620 $Y=576575
X48359 VSS: 2 VSS: 5939 4072 2 INVX16_HS $T=1208420 593400 0 0 $X=1208240 $Y=593135
X48362 VSS: 2 VSS: 6586 6070 2320 2558 6730 2 AOI22X1 $T=1203360 601680 0 180 $X=1200420 $Y=597235
X48375 VSS: 2 VSS: 6732 6731 1991 1990 6421 2 AOI22X1 $T=1201520 609960 1 0 $X=1201340 $Y=605515
X48386 VSS: 2 VSS: 6590 6733 6732 5118 6734 2 NAND4X1 $T=1204280 609960 1 180 $X=1201340 $Y=609695
X48400 VSS: 2 VSS: 6184 1690 6731 6174 4296 2 AOI22X2_HS $T=1204740 618240 0 0 $X=1204560 $Y=617975
X48436 VSS: 2 VSS: 538 6735 2 BUFX16_HS $T=1214860 13800 1 0 $X=1214680 $Y=9355
X48440 VSS: 2 VSS: 6735 6736 6738 2 NAND2X2_HS $T=1219460 13800 1 180 $X=1216060 $Y=13535
X48441 VSS: 2 VSS: 6738 6596 6737 2 NOR2X2_HS $T=1219460 13800 0 0 $X=1219280 $Y=13535
X48451 VSS: 2 VSS: 6737 6892 6739 6893 2 NAND3X2_HS $T=1227740 22080 1 0 $X=1227560 $Y=17635
X48454 VSS: 2 VSS: 6736 5666 6740 2 NOR2X2_HS $T=1216700 22080 0 0 $X=1216520 $Y=21815
X48458 VSS: 2 VSS: 6893 4175 6741 6285 6612 2 AOI22X2_HS $T=1227740 22080 0 0 $X=1227560 $Y=21815
X48464 VSS: 2 VSS: 6739 3790 6600 6201 3810 2 AOI22X2 $T=1219920 30360 1 0 $X=1219740 $Y=25915
X48477 VSS: 2 VSS: 6743 5817 6201 6600 3721 2 AOI22X1_HS $T=1221300 38640 1 0 $X=1221120 $Y=34195
X48481 VSS: 2 VSS: 6896 6743 6744 2 AND2X1_HS $T=1227740 38640 1 0 $X=1227560 $Y=34195
X48486 VSS: 2 VSS: 6744 5984 6601 6442 5275 2 AOI22X2_HS $T=1225440 38640 0 0 $X=1225260 $Y=38375
X48492 VSS: 2 VSS: 6747 6745 5950 6746 5807 2 NAND4X1 $T=1218540 46920 0 180 $X=1215600 $Y=42475
X48498 VSS: 2 VSS: 6748 6449 6747 6453 2 NOR3X1 $T=1214400 46920 0 0 $X=1214220 $Y=46655
X48504 VSS: 2 VSS: 6898 4660 4929 6601 6442 2 AOI22X1_HS $T=1227280 46920 0 0 $X=1227100 $Y=46655
X48511 VSS: 2 VSS: 6298 6749 1695 1716 6741 2 AOI22X1 $T=1219000 55200 0 180 $X=1216060 $Y=50755
X48516 VSS: 2 VSS: 6454 6750 1695 1716 6751 2 AOI22X1 $T=1220380 55200 1 180 $X=1217440 $Y=54935
X48525 VSS: 2 VSS: 6752 6753 6456 6749 5713 2 AOI22X2 $T=1221300 63480 0 180 $X=1216520 $Y=59035
X48532 VSS: 2 VSS: 6754 6753 6455 6750 5713 2 AOI22X2_HS $T=1219920 63480 0 0 $X=1219740 $Y=63215
X48539 VSS: 2 VSS: 6451 6755 6911 6754 6909 2 NAND4X4_HS $T=1226360 71760 1 0 $X=1226180 $Y=67315
X48542 VSS: 2 VSS: 6756 5331 6456 6749 5130 2 AOI22X2_HS $T=1222680 71760 1 180 $X=1216980 $Y=71495
X48546 VSS: 2 VSS: 6755 3476 6301 6912 6761 2 AOI22X2_HS $T=1233260 71760 1 180 $X=1227560 $Y=71495
X48552 VSS: 2 VSS: 6438 6760 6759 6758 6757 2 NAND4X4_HS $T=1229580 80040 0 180 $X=1220660 $Y=75595
X48561 VSS: 2 VSS: 6750 8140 4463 6648 2 DFFX1_HS $T=1217620 88320 1 0 $X=1217440 $Y=83875
X48565 VSS: 2 VSS: 6749 7410 4461 6648 2 DFFX4_HS $T=1217160 88320 0 0 $X=1216980 $Y=88055
X48570 VSS: 2 VSS: 6741 7411 4461 5914 2 DFFX4_HS $T=1214400 96600 1 0 $X=1214220 $Y=92155
X48571 VSS: 2 VSS: 6751 8141 4463 5914 2 DFFX1_HS $T=1225900 96600 1 0 $X=1225720 $Y=92155
X48576 VSS: 2 VSS: 6762 5331 5130 6763 6469 2 AOI22X2_HS $T=1228200 96600 1 180 $X=1222500 $Y=96335
X48584 VSS: 2 VSS: 6308 6763 1695 1716 6611 2 AOI22X1 $T=1219460 104880 1 0 $X=1219280 $Y=100435
X48588 VSS: 2 VSS: 6107 6925 6765 6766 6764 2 NAND4X2_HS $T=1231880 104880 1 180 $X=1226180 $Y=104615
X48596 VSS: 2 VSS: 6766 3476 6310 6768 6767 2 AOI22X2_HS $T=1228200 113160 0 180 $X=1222500 $Y=108715
X48601 VSS: 2 VSS: 6764 6753 6469 6763 6769 2 AOI22X2_HS $T=1219460 113160 0 0 $X=1219280 $Y=112895
X48609 VSS: 2 VSS: 6763 7412 4396 6648 2 DFFX4_HS $T=1216700 121440 1 0 $X=1216520 $Y=116995
X48611 VSS: 2 VSS: 6908 7413 4461 5385 2 DFFX4_HS $T=1228660 121440 1 0 $X=1228480 $Y=116995
X48616 VSS: 2 VSS: 6466 6770 2006 2007 6614 2 AOI22X1 $T=1223140 121440 0 0 $X=1222960 $Y=121175
X48622 VSS: 2 VSS: 6768 7414 4396 5385 2 DFFX4_HS $T=1222220 129720 1 0 $X=1222040 $Y=125275
X48624 VSS: 2 VSS: 6759 5503 6771 6772 5500 2 AOI22X2_HS $T=1229120 129720 1 180 $X=1223420 $Y=129455
X48629 VSS: 2 VSS: 6320 6773 1695 1716 6617 2 AOI22X1 $T=1213940 138000 1 0 $X=1213760 $Y=133555
X48635 VSS: 2 VSS: 6773 7415 4530 6648 2 DFFX4_HS $T=1227280 138000 1 0 $X=1227100 $Y=133555
X48641 VSS: 2 VSS: 6774 5331 5130 6773 6472 2 AOI22X2_HS $T=1228660 138000 1 180 $X=1222960 $Y=137735
X48649 VSS: 2 VSS: 6475 6776 2006 2007 6619 2 AOI22X1 $T=1223140 146280 1 0 $X=1222960 $Y=141835
X48661 VSS: 2 VSS: 6777 3476 6323 6933 6761 2 AOI22X2_HS $T=1231420 154560 0 180 $X=1225720 $Y=150115
X48664 VSS: 2 VSS: 6778 6753 6472 6773 6779 2 AOI22X2_HS $T=1221300 154560 1 180 $X=1215600 $Y=154295
X48668 VSS: 2 VSS: 5973 6935 6934 6777 6778 2 NAND4X4_HS $T=1233260 154560 1 180 $X=1224340 $Y=154295
X48675 VSS: 2 VSS: 6770 7416 4396 5393 2 DFFX4_HS $T=1219000 162840 0 0 $X=1218820 $Y=162575
X48680 VSS: 2 VSS: 6776 7417 4530 5393 2 DFFX4_HS $T=1219000 171120 1 0 $X=1218820 $Y=166675
X48684 VSS: 2 VSS: 6933 7418 4530 5385 2 DFFX4_HS $T=1224520 171120 0 0 $X=1224340 $Y=170855
X48690 VSS: 2 VSS: 6335 6782 1695 1716 6626 2 AOI22X1 $T=1214860 179400 1 0 $X=1214680 $Y=174955
X48694 VSS: 2 VSS: 6781 5331 5130 6782 6483 2 AOI22X2_HS $T=1228200 179400 0 180 $X=1222500 $Y=174955
X48700 VSS: 2 VSS: 6782 8142 4331 6648 2 DFFX1_HS $T=1219920 179400 0 0 $X=1219740 $Y=179135
X48709 VSS: 2 VSS: 6783 6753 6483 6782 6779 2 AOI22X2_HS $T=1227740 187680 1 180 $X=1222040 $Y=187415
X48716 VSS: 2 VSS: 6485 6784 2006 2007 6624 2 AOI22X1 $T=1219920 195960 1 0 $X=1219740 $Y=191515
X48720 VSS: 2 VSS: 6624 8143 4331 5860 2 DFFX1_HS $T=1213940 195960 0 0 $X=1213760 $Y=195695
X48721 VSS: 2 VSS: 6784 8144 4331 5393 2 DFFX1_HS $T=1223140 195960 0 0 $X=1222960 $Y=195695
X48725 VSS: 2 VSS: 5713 3540 2 BUFX8_HS $T=1218540 204240 0 180 $X=1212840 $Y=199795
X48730 VSS: 2 VSS: 6942 8145 4331 5385 2 DFFX1_HS $T=1228660 204240 1 0 $X=1228480 $Y=199795
X48733 VSS: 2 VSS: 6779 3540 2 BUFX16_HS $T=1219460 204240 0 0 $X=1219280 $Y=203975
X48739 VSS: 2 VSS: 6785 6495 6786 2 NOR2X2_HS $T=1215780 212520 1 0 $X=1215600 $Y=208075
X48743 VSS: 2 VSS: 6769 3540 2 BUFX8_HS $T=1222220 212520 1 0 $X=1222040 $Y=208075
X48745 VSS: 2 VSS: 6950 7419 4920 5385 2 DFFX4_HS $T=1228660 212520 1 0 $X=1228480 $Y=208075
X48748 VSS: 2 VSS: 6787 7420 4920 6648 2 DFFX4_HS $T=1217620 212520 0 0 $X=1217440 $Y=212255
X48753 VSS: 2 VSS: 6634 6635 6785 2 NAND2X2_HS $T=1216240 220800 0 180 $X=1212840 $Y=216355
X48756 VSS: 2 VSS: 6789 5331 5103 6787 6499 2 AOI22X2 $T=1223600 220800 0 180 $X=1218820 $Y=216355
X48758 VSS: 2 VSS: 6786 6790 6789 6788 6954 2 NAND4X2_HS $T=1227280 220800 1 0 $X=1227100 $Y=216355
X48761 VSS: 2 VSS: 6788 5700 6482 6950 6791 2 AOI22X2 $T=1230960 220800 1 180 $X=1226180 $Y=220535
X48768 VSS: 2 VSS: 6792 6793 6499 6787 6779 2 AOI22X2 $T=1221300 229080 1 0 $X=1221120 $Y=224635
X48774 VSS: 2 VSS: 6638 6787 1695 1716 6795 2 AOI22X1 $T=1224060 229080 1 180 $X=1221120 $Y=228815
X48781 VSS: 2 VSS: 6795 7421 4920 5914 2 DFFX4_HS $T=1215320 237360 1 0 $X=1215140 $Y=232915
X48787 VSS: 2 VSS: 6796 7422 4920 5393 2 DFFX4_HS $T=1223140 237360 0 0 $X=1222960 $Y=237095
X48795 VSS: 2 VSS: 6798 6796 2006 2007 6799 2 AOI22X1 $T=1225900 245640 1 0 $X=1225720 $Y=241195
X48800 VSS: 2 VSS: 6800 5787 6795 6347 5846 2 AOI22X2 $T=1222220 245640 0 0 $X=1222040 $Y=245375
X48805 VSS: 2 VSS: 6635 6801 6645 2 NOR2X2_HS $T=1216700 253920 0 180 $X=1213300 $Y=249475
X48813 VSS: 2 VSS: 6799 7423 4920 5860 2 DFFX4_HS $T=1218080 253920 0 0 $X=1217900 $Y=253655
X48820 VSS: 2 VSS: 6793 4705 2 BUFX2_HS $T=1224520 262200 0 180 $X=1221580 $Y=257755
X48823 VSS: 2 VSS: 6965 7424 4536 5385 2 DFFX4_HS $T=1226820 262200 1 0 $X=1226640 $Y=257755
X48835 VSS: 2 VSS: 6642 6802 2013 2012 6649 2 AOI22X1 $T=1217160 270480 1 0 $X=1216980 $Y=266035
X48838 VSS: 2 VSS: 6816 7425 4504 5385 2 DFFX4_HS $T=1227280 270480 1 0 $X=1227100 $Y=266035
X48840 VSS: 2 VSS: 6802 7426 4920 6290 2 DFFX4_HS $T=1213480 270480 0 0 $X=1213300 $Y=270215
X48843 VSS: 2 VSS: 6791 4840 2 BUFX4_HS $T=1227740 270480 0 0 $X=1227560 $Y=270215
X48854 VSS: 2 VSS: 6753 4705 2 BUFX16_HS $T=1219460 278760 0 0 $X=1219280 $Y=278495
X48861 VSS: 2 VSS: 6804 6753 6666 6803 6769 2 AOI22X2_HS $T=1219920 287040 1 0 $X=1219740 $Y=282595
X48866 VSS: 2 VSS: 6805 5331 5103 6803 6666 2 AOI22X2 $T=1221760 287040 0 0 $X=1221580 $Y=286775
X48874 VSS: 2 VSS: 6807 3756 6225 6965 6761 2 AOI22X2 $T=1230960 295320 0 180 $X=1226180 $Y=290875
X48877 VSS: 2 VSS: 6666 7427 4536 6608 2 DFFX4_HS $T=1216240 295320 0 0 $X=1216060 $Y=295055
X48879 VSS: 2 VSS: 6806 6977 6980 6807 6804 2 NAND4X2_HS $T=1234180 295320 1 180 $X=1228480 $Y=295055
X48887 VSS: 2 VSS: 6803 7428 4536 6648 2 DFFX4_HS $T=1220840 303600 1 0 $X=1220660 $Y=299155
X48891 VSS: 2 VSS: 6979 7429 4536 5393 2 DFFX4_HS $T=1220840 303600 0 0 $X=1220660 $Y=303335
X48902 VSS: 2 VSS: 6661 6803 1695 1716 6810 2 AOI22X1 $T=1225440 311880 1 180 $X=1222500 $Y=311615
X48909 VSS: 2 VSS: 6812 6517 6811 6660 2 NOR3X1 $T=1216240 320160 1 0 $X=1216060 $Y=315715
X48911 VSS: 2 VSS: 6810 7430 4536 5914 2 DFFX4_HS $T=1222220 320160 1 0 $X=1222040 $Y=315715
X48916 VSS: 2 VSS: 6811 6813 6357 6814 6359 2 NAND4X1 $T=1224980 320160 1 180 $X=1222040 $Y=319895
X48926 VSS: 2 VSS: 6813 6815 2013 2012 6659 2 AOI22X1 $T=1222680 328440 1 0 $X=1222500 $Y=323995
X48929 VSS: 2 VSS: 6815 7431 4536 6290 2 DFFX4_HS $T=1216240 328440 0 0 $X=1216060 $Y=328175
X48931 VSS: 2 VSS: 6985 7432 4504 5393 2 DFFX4_HS $T=1228660 328440 0 0 $X=1228480 $Y=328175
X48937 VSS: 2 VSS: 6767 4575 2 BUFX16_HS $T=1221760 336720 1 0 $X=1221580 $Y=332275
X48942 VSS: 2 VSS: 6817 7433 4504 6290 2 DFFX4_HS $T=1216700 336720 0 0 $X=1216520 $Y=336455
X48951 VSS: 2 VSS: 6818 3756 6227 6816 6761 2 AOI22X2 $T=1229120 345000 0 180 $X=1224340 $Y=340555
X48956 VSS: 2 VSS: 6761 4575 2 BUFX16_HS $T=1222220 345000 0 0 $X=1222040 $Y=344735
X48961 VSS: 2 VSS: 6821 8146 5258 6290 2 DFFX1_HS $T=1217160 353280 1 0 $X=1216980 $Y=348835
X48963 VSS: 2 VSS: 6820 6993 6992 6818 6819 2 NAND4X2_HS $T=1232340 353280 0 180 $X=1226640 $Y=348835
X48967 VSS: 2 VSS: 6819 5876 6673 6824 5877 2 AOI22X2 $T=1216700 353280 0 0 $X=1216520 $Y=353015
X48970 VSS: 2 VSS: 6823 6673 6824 5103 5104 2 AOI22X1 $T=1225440 353280 0 0 $X=1225260 $Y=353015
X48978 VSS: 2 VSS: 2078 6995 2 BUFX16_HS $T=1232800 361560 0 180 $X=1222500 $Y=357115
X48981 VSS: 2 VSS: 6824 7434 4504 6648 2 DFFX4_HS $T=1216700 361560 0 0 $X=1216520 $Y=361295
X48991 VSS: 2 VSS: 6826 6825 6820 2 NOR2X2_HS $T=1225900 369840 1 0 $X=1225720 $Y=365395
X48995 VSS: 2 VSS: 6827 6676 6828 6829 2 NOR3X1 $T=1221300 369840 0 0 $X=1221120 $Y=369575
X49004 VSS: 2 VSS: 6677 6824 1695 1716 6830 2 AOI22X1 $T=1225440 378120 0 180 $X=1222500 $Y=373675
X49011 VSS: 2 VSS: 6828 6831 6374 6832 6376 2 NAND4X1 $T=1227740 378120 1 180 $X=1224800 $Y=377855
X49019 VSS: 2 VSS: 6830 7435 4504 5914 2 DFFX4_HS $T=1221760 386400 1 0 $X=1221580 $Y=381955
X49023 VSS: 2 VSS: 2618 7006 2 BUFX16_HS $T=1233260 386400 1 180 $X=1222960 $Y=386135
X49031 VSS: 2 VSS: 6831 6817 2013 2012 6394 2 AOI22X1 $T=1224520 394680 1 0 $X=1224340 $Y=390235
X49035 VSS: 2 VSS: 6631 1690 2 BUFX16_HS $T=1230500 394680 1 180 $X=1220200 $Y=394415
X49040 VSS: 2 VSS: 2478 6833 2 BUFX16_HS $T=1214400 402960 1 0 $X=1214220 $Y=398515
X49045 VSS: 2 VSS: 6833 6835 6836 2 NAND2X2_HS $T=1219920 402960 1 180 $X=1216520 $Y=402695
X49048 VSS: 2 VSS: 6835 6687 6834 2 NOR2X2_HS $T=1224520 402960 0 0 $X=1224340 $Y=402695
X49057 VSS: 2 VSS: 6837 6821 2013 2012 6393 2 AOI22X1 $T=1222680 411240 1 0 $X=1222500 $Y=406795
X49062 VSS: 2 VSS: 2912 6838 2 BUFX16_HS $T=1222680 411240 0 0 $X=1222500 $Y=410975
X49070 VSS: 2 VSS: 6838 6840 6839 2 NAND2X2_HS $T=1226360 419520 1 0 $X=1226180 $Y=415075
X49075 VSS: 2 VSS: 6840 6841 6542 2 NOR2X2_HS $T=1229580 419520 1 180 $X=1226180 $Y=419255
X49081 VSS: 2 VSS: 6844 8147 5258 5914 2 DFFX1_HS $T=1222220 427800 1 0 $X=1222040 $Y=423355
X49084 VSS: 2 VSS: 6843 6837 6386 6842 6389 2 NAND4X1 $T=1223600 427800 1 180 $X=1220660 $Y=427535
X49094 VSS: 2 VSS: 6695 6845 1695 1716 6844 2 AOI22X1 $T=1227280 436080 0 180 $X=1224340 $Y=431635
X49097 VSS: 2 VSS: 6846 6697 6843 6696 2 NOR3X1 $T=1216700 436080 0 0 $X=1216520 $Y=435815
X49100 VSS: 2 VSS: 6845 8148 5258 6648 2 DFFX1_HS $T=1223600 436080 0 0 $X=1223420 $Y=435815
X49108 VSS: 2 VSS: 6839 6700 6847 2 NOR2X2_HS $T=1225900 444360 1 0 $X=1225720 $Y=439915
X49111 VSS: 2 VSS: 6848 5876 6702 6845 5877 2 AOI22X2 $T=1228200 444360 1 180 $X=1223420 $Y=444095
X49119 VSS: 2 VSS: 6836 6553 6849 2 NOR2X2_HS $T=1217620 452640 1 0 $X=1217440 $Y=448195
X49123 VSS: 2 VSS: 6850 5104 6702 6845 5103 2 AOI22X1_HS $T=1224060 452640 1 0 $X=1223880 $Y=448195
X49125 VSS: 2 VSS: 6849 6851 7018 6850 7020 2 NAND4X2_HS $T=1228200 452640 1 0 $X=1228020 $Y=448195
X49131 VSS: 2 VSS: 5877 3540 2 BUFX16_HS $T=1228200 452640 0 0 $X=1228020 $Y=452375
X49136 VSS: 2 VSS: 6852 3840 6557 6398 5821 2 AOI22X2_HS $T=1213020 460920 1 0 $X=1212840 $Y=456475
X49141 VSS: 2 VSS: 6853 7436 4880 6648 2 DFFX4_HS $T=1216240 460920 0 0 $X=1216060 $Y=460655
X49149 VSS: 2 VSS: 6854 5104 5103 6853 6559 2 AOI22X2 $T=1224060 469200 1 0 $X=1223880 $Y=464755
X49154 VSS: 2 VSS: 6855 5876 6559 6853 5877 2 AOI22X2_HS $T=1222220 469200 0 0 $X=1222040 $Y=468935
X49155 VSS: 2 VSS: 6936 5454 2 CLKBUFX8 $T=1227740 469200 0 0 $X=1227560 $Y=468935
X49174 VSS: 2 VSS: 6859 6856 6858 2 NOR2X2_HS $T=1218080 485760 1 0 $X=1217900 $Y=481315
X49182 VSS: 2 VSS: 7031 3756 6268 6411 5294 2 AOI22X2_HS $T=1233720 485760 1 180 $X=1228020 $Y=485495
X49188 VSS: 2 VSS: 6860 7437 4883 6648 2 DFFX4_HS $T=1216240 494040 1 0 $X=1216060 $Y=489595
X49191 VSS: 2 VSS: 6712 6862 6564 6861 6404 2 NAND4X1 $T=1217160 494040 1 180 $X=1214220 $Y=493775
X49203 VSS: 2 VSS: 2888 6863 2 BUFX16_HS $T=1219920 502320 1 0 $X=1219740 $Y=497875
X49207 VSS: 2 VSS: 6863 6864 6859 2 NAND2X4_HS $T=1227740 502320 1 180 $X=1222500 $Y=502055
X49219 VSS: 2 VSS: 6864 6867 6866 2 NOR2X4_HS $T=1227280 510600 1 180 $X=1222040 $Y=510335
X49224 VSS: 2 VSS: 6869 6853 1695 1716 6868 2 AOI22X1 $T=1216700 518880 0 180 $X=1213760 $Y=514435
X49229 VSS: 2 VSS: 6711 6869 6870 6410 6865 2 NAND4X1 $T=1213020 518880 0 0 $X=1212840 $Y=518615
X49235 VSS: 2 VSS: 7035 4840 2 BUFX8_HS $T=1228200 518880 0 0 $X=1228020 $Y=518615
X49241 VSS: 2 VSS: 6868 7438 4880 5914 2 DFFX4_HS $T=1216700 527160 1 0 $X=1216520 $Y=522715
X49244 VSS: 2 VSS: 6870 6871 1991 1990 6398 2 AOI22X1 $T=1213940 527160 0 0 $X=1213760 $Y=526895
X49248 VSS: 2 VSS: 6872 3756 6270 6412 5294 2 AOI22X2_HS $T=1233260 527160 1 180 $X=1227560 $Y=526895
X49254 VSS: 2 VSS: 6873 7439 3904 5914 2 DFFX4_HS $T=1215320 535440 1 0 $X=1215140 $Y=530995
X49258 VSS: 2 VSS: 6874 7440 4883 5914 2 DFFX4_HS $T=1220840 535440 0 0 $X=1220660 $Y=535175
X49263 VSS: 2 VSS: 6720 7441 4883 6608 2 DFFX4_HS $T=1216700 543720 1 0 $X=1216520 $Y=539275
X49265 VSS: 2 VSS: 6723 7046 6875 7042 7045 2 NAND4X2_HS $T=1228660 543720 1 0 $X=1228480 $Y=539275
X49266 VSS: 2 VSS: 6730 7442 3904 6608 2 DFFX4_HS $T=1214860 543720 0 0 $X=1214680 $Y=543455
X49269 VSS: 2 VSS: 7049 5876 6720 6860 5877 2 AOI22X2_HS $T=1228660 543720 0 0 $X=1228480 $Y=543455
X49276 VSS: 2 VSS: 6862 6272 2013 2012 6414 2 AOI22X1 $T=1225440 552000 1 0 $X=1225260 $Y=547555
X49282 VSS: 2 VSS: 6875 6720 6860 5103 5104 2 AOI22X1 $T=1229580 552000 1 180 $X=1226640 $Y=551735
X49286 VSS: 2 VSS: 5876 4705 2 BUFX16_HS $T=1216700 560280 1 0 $X=1216520 $Y=555835
X49292 VSS: 2 VSS: 6879 6878 6420 6877 6418 2 NAND4X1 $T=1226360 560280 0 0 $X=1226180 $Y=560015
X49299 VSS: 2 VSS: 6881 6860 1695 1716 6874 2 AOI22X1 $T=1222680 568560 0 180 $X=1219740 $Y=564115
X49305 VSS: 2 VSS: 1780 6882 2 BUFX16_HS $T=1225900 568560 1 180 $X=1215600 $Y=568295
X49310 VSS: 2 VSS: 6884 6881 6885 6417 6725 2 NAND4X1 $T=1213480 576840 1 0 $X=1213300 $Y=572395
X49316 VSS: 2 VSS: 6882 7052 6883 2 NAND2X2_HS $T=1230040 576840 0 180 $X=1226640 $Y=572395
X49321 VSS: 2 VSS: 7052 6718 7054 2 NOR2X2_HS $T=1227280 576840 0 0 $X=1227100 $Y=576575
X49325 VSS: 2 VSS: 6885 6876 1991 1990 6419 2 AOI22X1 $T=1214400 585120 1 0 $X=1214220 $Y=580675
X49335 VSS: 2 VSS: 6878 6277 2013 2012 6274 2 AOI22X1 $T=1225900 585120 0 0 $X=1225720 $Y=584855
X49341 VSS: 2 VSS: 6728 5471 3540 4705 6730 2 AOI22X2 $T=1216240 593400 1 0 $X=1216060 $Y=588955
X49357 VSS: 2 VSS: 6172 5103 5471 6730 6886 2 AOI22X2_HS $T=1224980 601680 1 0 $X=1224800 $Y=597235
X49360 VSS: 2 VSS: 6887 3534 4733 5472 5633 2 AOI22X2 $T=1220380 601680 0 0 $X=1220200 $Y=601415
X49368 VSS: 2 VSS: 6733 5471 1695 1716 6873 2 AOI22X1 $T=1223600 609960 0 180 $X=1220660 $Y=605515
X49381 VSS: 2 VSS: 6177 6174 2013 2012 6275 2 AOI22X1 $T=1222680 618240 1 0 $X=1222500 $Y=613795
X49395 VSS: 2 VSS: 6888 4914 6068 6275 4032 2 AOI22X2_HS $T=1227740 626520 0 180 $X=1222040 $Y=622075
X49400 VSS: 2 VSS: 6182 4216 6873 6572 3859 2 AOI22X2 $T=1227740 626520 1 180 $X=1222960 $Y=626255
X49410 VSS: 2 VSS: 6889 6873 6572 5026 5025 2 AOI22X1 $T=1227280 634800 1 0 $X=1227100 $Y=630355
X49414 VSS: 2 VSS: 5308 6888 6889 6887 7055 2 NAND4X4_HS $T=1224060 634800 0 0 $X=1223880 $Y=634535
X49430 VSS: 2 VSS: 6890 5814 6443 6286 6751 2 AOI22X2 $T=1241080 13800 1 0 $X=1240900 $Y=9355
X49436 VSS: 2 VSS: 6437 6890 6891 7057 7056 2 NAND4X2_HS $T=1243840 13800 0 0 $X=1243660 $Y=13535
X49442 VSS: 2 VSS: 7058 4175 6751 6286 6612 2 AOI22X2 $T=1242920 22080 1 0 $X=1242740 $Y=17635
X49454 VSS: 2 VSS: 6894 6741 6285 6443 5814 2 AOI22X1_HS $T=1233260 30360 0 0 $X=1233080 $Y=30095
X49460 VSS: 2 VSS: 6187 6896 6894 6895 2 NAND3X2_HS $T=1237400 38640 0 180 $X=1232620 $Y=34195
X49465 VSS: 2 VSS: 6891 5984 6607 6441 5275 2 AOI22X2_HS $T=1244300 38640 1 0 $X=1244120 $Y=34195
X49470 VSS: 2 VSS: 6447 6897 7059 7058 2 NAND3X2_HS $T=1247520 38640 1 180 $X=1242740 $Y=38375
X49472 VSS: 2 VSS: 6892 6899 6898 2 AND2X1_HS $T=1233260 46920 0 180 $X=1230320 $Y=42475
X49477 VSS: 2 VSS: 6897 7061 7060 2 AND2X1_HS $T=1247520 46920 0 180 $X=1244580 $Y=42475
X49482 VSS: 2 VSS: 7060 4660 6441 6607 4971 2 AOI22X1_HS $T=1245220 46920 0 0 $X=1245040 $Y=46655
X49483 VSS: 2 VSS: 6899 4374 6900 6901 4927 2 AOI22X2 $T=1234640 55200 0 180 $X=1229860 $Y=50755
X49488 VSS: 2 VSS: 7061 4969 7062 6902 4374 2 AOI22X2_HS $T=1243380 55200 1 0 $X=1243200 $Y=50755
X49490 VSS: 2 VSS: 6740 6903 6752 6905 6904 2 NAND4X2_HS $T=1231880 55200 0 0 $X=1231700 $Y=54935
X49494 VSS: 2 VSS: 7056 6613 6902 7062 4367 2 AOI22X2_HS $T=1250740 55200 1 180 $X=1245040 $Y=54935
X49496 VSS: 2 VSS: 6895 4367 6613 6900 6901 2 AOI22X2 $T=1230040 63480 1 0 $X=1229860 $Y=59035
X49501 VSS: 2 VSS: 6903 4140 6907 7063 6906 2 AOI22X1 $T=1244300 63480 1 0 $X=1244120 $Y=59035
X49505 VSS: 2 VSS: 6905 3476 6205 6908 6761 2 AOI22X2 $T=1238780 63480 1 180 $X=1234000 $Y=63215
X49511 VSS: 2 VSS: 6909 6906 6910 7065 4140 2 AOI22X2 $T=1247980 71760 0 180 $X=1243200 $Y=67315
X49514 VSS: 2 VSS: 6080 6915 6913 6756 6914 2 NAND4X4_HS $T=1237400 71760 0 0 $X=1237220 $Y=71495
X49517 VSS: 2 VSS: 6760 5700 6301 6912 5251 2 AOI22X2 $T=1236940 80040 0 180 $X=1232160 $Y=75595
X49520 VSS: 2 VSS: 6758 5287 7065 6910 6944 2 AOI22X2_HS $T=1242460 80040 1 0 $X=1242280 $Y=75595
X49524 VSS: 2 VSS: 6915 5700 6205 6908 5251 2 AOI22X2 $T=1240620 80040 1 180 $X=1235840 $Y=79775
X49529 VSS: 2 VSS: 6746 6772 2006 2007 6902 2 AOI22X1 $T=1237400 88320 0 180 $X=1234460 $Y=83875
X49534 VSS: 2 VSS: 6445 6916 2006 2007 6900 2 AOI22X1 $T=1236940 88320 1 180 $X=1234000 $Y=88055
X49538 VSS: 2 VSS: 6918 6917 5252 2 NAND2X1 $T=1245220 88320 1 180 $X=1243200 $Y=88055
X49541 VSS: 2 VSS: 6911 4207 6772 6771 6919 2 AOI22X2_HS $T=1241540 96600 0 180 $X=1235840 $Y=92155
X49546 VSS: 2 VSS: 6904 3855 6916 6920 6919 2 AOI22X2_HS $T=1241540 96600 1 180 $X=1235840 $Y=96335
X49550 VSS: 2 VSS: 5685 6924 6923 6921 6762 2 NAND4X4_HS $T=1240160 104880 0 180 $X=1231240 $Y=100435
X49557 VSS: 2 VSS: 6765 4140 6926 6922 6906 2 AOI22X1_HS $T=1247060 104880 1 180 $X=1243660 $Y=104615
X49559 VSS: 2 VSS: 6924 5700 6310 6768 5251 2 AOI22X2_HS $T=1241080 113160 0 180 $X=1235380 $Y=108715
X49563 VSS: 2 VSS: 6912 8149 4463 5385 2 DFFX1_HS $T=1230040 113160 0 0 $X=1229860 $Y=112895
X49566 VSS: 2 VSS: 7065 8150 4463 5018 2 DFFX1_HS $T=1240160 121440 1 0 $X=1239980 $Y=116995
X49571 VSS: 2 VSS: 6925 4207 6770 6927 6919 2 AOI22X2_HS $T=1242000 121440 1 180 $X=1236300 $Y=121175
X49574 VSS: 2 VSS: 6923 5503 6927 6770 5373 2 AOI22X2_HS $T=1235560 129720 1 0 $X=1235380 $Y=125275
X49576 VSS: 2 VSS: 6926 7443 4396 5018 2 DFFX4_HS $T=1242920 129720 1 0 $X=1242740 $Y=125275
X49580 VSS: 2 VSS: 6913 5503 6920 6916 5373 2 AOI22X2_HS $T=1235560 129720 0 0 $X=1235380 $Y=129455
X49584 VSS: 2 VSS: 7063 7444 4461 5714 2 DFFX4_HS $T=1244300 129720 0 0 $X=1244120 $Y=129455
X49588 VSS: 2 VSS: 6775 7445 4530 6928 2 DFFX4_HS $T=1242000 138000 1 0 $X=1241820 $Y=133555
X49591 VSS: 2 VSS: 5697 6931 6774 6930 6929 2 NAND4X4_HS $T=1233720 138000 0 0 $X=1233540 $Y=137735
X49593 VSS: 2 VSS: 6615 7446 4396 6928 2 DFFX4_HS $T=1242920 138000 0 0 $X=1242740 $Y=137735
X49596 VSS: 2 VSS: 6931 5503 6932 6776 5373 2 AOI22X2_HS $T=1235100 146280 1 0 $X=1234920 $Y=141835
X49601 VSS: 2 VSS: 6930 5700 6323 6933 5251 2 AOI22X2_HS $T=1240620 146280 1 180 $X=1234920 $Y=146015
X49606 VSS: 2 VSS: 6902 8151 4463 5860 2 DFFX1_HS $T=1236020 154560 1 0 $X=1235840 $Y=150115
X49608 VSS: 2 VSS: 6900 7447 4461 5860 2 DFFX4_HS $T=1233260 154560 0 0 $X=1233080 $Y=154295
X49609 VSS: 2 VSS: 6927 7448 4396 6936 2 DFFX4_HS $T=1244760 154560 0 0 $X=1244580 $Y=154295
X49611 VSS: 2 VSS: 6934 4207 6776 6932 6937 2 AOI22X2_HS $T=1238780 162840 0 180 $X=1233080 $Y=158395
X49615 VSS: 2 VSS: 6932 7449 4530 6936 2 DFFX4_HS $T=1243840 162840 1 0 $X=1243660 $Y=158395
X49617 VSS: 2 VSS: 6916 7450 4461 5393 2 DFFX4_HS $T=1230960 162840 0 0 $X=1230780 $Y=162575
X49620 VSS: 2 VSS: 6772 8152 4463 5393 2 DFFX1_HS $T=1230960 171120 1 0 $X=1230780 $Y=166675
X49623 VSS: 2 VSS: 6935 4140 7086 6938 6906 2 AOI22X2_HS $T=1244300 171120 1 0 $X=1244120 $Y=166675
X49627 VSS: 2 VSS: 6929 5287 7086 6938 6944 2 AOI22X2_HS $T=1243840 171120 0 0 $X=1243660 $Y=170855
X49629 VSS: 2 VSS: 5820 6939 6941 6781 6940 2 NAND4X4_HS $T=1230960 179400 1 0 $X=1230780 $Y=174955
X49634 VSS: 2 VSS: 6941 5700 6324 6942 5251 2 AOI22X2 $T=1237400 179400 1 180 $X=1232620 $Y=179135
X49637 VSS: 2 VSS: 7086 7451 4530 5018 2 DFFX4_HS $T=1241540 179400 0 0 $X=1241360 $Y=179135
X49640 VSS: 2 VSS: 6943 3476 6324 6942 6767 2 AOI22X2_HS $T=1237400 187680 0 180 $X=1231700 $Y=183235
X49643 VSS: 2 VSS: 6940 6944 5287 6948 7087 2 AOI22X2_HS $T=1244760 187680 1 0 $X=1244580 $Y=183235
X49645 VSS: 2 VSS: 6217 6943 6946 6945 6783 2 NAND4X4_HS $T=1239240 187680 1 180 $X=1230320 $Y=187415
X49648 VSS: 2 VSS: 6945 4140 6948 7087 6906 2 AOI22X2 $T=1249360 187680 1 180 $X=1244580 $Y=187415
X49651 VSS: 2 VSS: 6946 4207 6784 6947 6937 2 AOI22X2_HS $T=1241080 195960 0 180 $X=1235380 $Y=191515
X49653 VSS: 2 VSS: 6948 8153 4331 5018 2 DFFX1_HS $T=1244760 195960 1 0 $X=1244580 $Y=191515
X49657 VSS: 2 VSS: 6939 5503 6947 6784 5500 2 AOI22X2_HS $T=1235560 195960 0 0 $X=1235380 $Y=195695
X49662 VSS: 2 VSS: 6949 6942 2312 2311 6948 2 AOI22X1 $T=1246140 204240 0 180 $X=1243200 $Y=199795
X49664 VSS: 2 VSS: 6937 3313 2 BUFX16_HS $T=1240620 204240 1 180 $X=1230320 $Y=203975
X49665 VSS: 2 VSS: 6919 3313 2 BUFX16_HS $T=1240620 204240 0 0 $X=1240440 $Y=203975
X49669 VSS: 2 VSS: 6944 5016 2 BUFX16_HS $T=1243380 212520 1 0 $X=1243200 $Y=208075
X49674 VSS: 2 VSS: 6952 6633 6951 2 NOR2X2_HS $T=1239240 212520 1 180 $X=1235840 $Y=212255
X49678 VSS: 2 VSS: 6616 3497 2 BUFX16_HS $T=1245220 212520 0 0 $X=1245040 $Y=212255
X49680 VSS: 2 VSS: 2427 6953 2 BUFX16_HS $T=1236480 220800 1 0 $X=1236300 $Y=216355
X49684 VSS: 2 VSS: 6953 6955 6952 2 NAND2X2_HS $T=1242460 220800 1 180 $X=1239060 $Y=220535
X49688 VSS: 2 VSS: 6951 6956 6957 6792 6958 2 NAND4X2_HS $T=1233720 229080 1 0 $X=1233540 $Y=224635
X49692 VSS: 2 VSS: 6957 3756 6482 6950 6767 2 AOI22X2 $T=1232340 229080 0 0 $X=1232160 $Y=228815
X49696 VSS: 2 VSS: 6956 6906 7094 7093 5538 2 AOI22X2 $T=1249820 229080 1 180 $X=1245040 $Y=228815
X49697 VSS: 2 VSS: 6790 5503 6959 6796 5500 2 AOI22X2_HS $T=1229580 237360 1 0 $X=1229400 $Y=232915
X49702 VSS: 2 VSS: 6955 6960 6639 2 NOR2X2_HS $T=1245220 237360 0 180 $X=1241820 $Y=232915
X49705 VSS: 2 VSS: 6958 4207 6796 6959 6961 2 AOI22X2_HS $T=1242000 237360 1 180 $X=1236300 $Y=237095
X49712 VSS: 2 VSS: 7102 4927 7097 6799 6616 2 AOI22X2_HS $T=1244760 245640 1 0 $X=1244580 $Y=241195
X49717 VSS: 2 VSS: 6960 7103 6800 7104 7102 2 NAND4X2_HS $T=1250740 245640 1 180 $X=1245040 $Y=245375
X49718 VSS: 2 VSS: 6963 6795 6347 6443 5814 2 AOI22X1_HS $T=1229120 253920 1 0 $X=1228940 $Y=249475
X49723 VSS: 2 VSS: 6962 6613 6799 7097 6984 2 AOI22X2_HS $T=1249360 253920 0 180 $X=1243660 $Y=249475
X49729 VSS: 2 VSS: 7104 6508 6649 4971 4660 2 AOI22X2 $T=1245220 253920 0 0 $X=1245040 $Y=253655
X49732 VSS: 2 VSS: 6801 6964 6962 6963 7105 2 NAND4X2_HS $T=1243840 262200 1 0 $X=1243660 $Y=257755
X49750 VSS: 2 VSS: 5846 3859 2 BUFX8_HS $T=1237860 278760 1 0 $X=1237680 $Y=274315
X49754 VSS: 2 VSS: 6966 6791 6816 6227 5700 2 AOI22X1 $T=1233720 278760 1 180 $X=1230780 $Y=278495
X49757 VSS: 2 VSS: 2866 6967 2 BUFX16_HS $T=1236020 278760 0 0 $X=1235840 $Y=278495
X49761 VSS: 2 VSS: 6967 6968 6969 2 NAND2X2_HS $T=1238320 287040 0 180 $X=1234920 $Y=282595
X49764 VSS: 2 VSS: 6968 6970 6652 2 NOR2X2_HS $T=1242920 287040 0 180 $X=1239520 $Y=282595
X49768 VSS: 2 VSS: 6971 5700 6225 6965 6791 2 AOI22X2 $T=1231420 287040 0 0 $X=1231240 $Y=286775
X49771 VSS: 2 VSS: 6972 5016 2 BUFX2 $T=1243380 287040 0 0 $X=1243200 $Y=286775
X49774 VSS: 2 VSS: 6969 6973 6670 2 NOR2X2_HS $T=1238320 295320 0 180 $X=1234920 $Y=290875
X49776 VSS: 2 VSS: 6973 6971 6805 6975 6976 2 NAND4X2_HS $T=1239240 295320 1 0 $X=1239060 $Y=290875
X49779 VSS: 2 VSS: 6975 5503 6978 6979 5500 2 AOI22X2_HS $T=1236020 295320 0 0 $X=1235840 $Y=295055
X49781 VSS: 2 VSS: 6980 6906 7109 7106 5538 2 AOI22X2 $T=1249820 295320 1 180 $X=1245040 $Y=295055
X49783 VSS: 2 VSS: 6977 4207 6979 6978 6961 2 AOI22X2_HS $T=1241540 303600 0 180 $X=1235840 $Y=299155
X49789 VSS: 2 VSS: 6981 6810 6356 6443 5814 2 AOI22X1_HS $T=1238320 303600 0 0 $X=1238140 $Y=303335
X49801 VSS: 2 VSS: 6809 6986 7117 7118 6982 2 NAND4X2_HS $T=1249360 311880 1 180 $X=1243660 $Y=311615
X49805 VSS: 2 VSS: 6814 6979 2006 2007 6983 2 AOI22X1 $T=1239700 320160 0 180 $X=1236760 $Y=315715
X49808 VSS: 2 VSS: 7118 4374 6983 7116 4927 2 AOI22X2 $T=1249820 320160 0 180 $X=1245040 $Y=315715
X49817 VSS: 2 VSS: 6982 5787 6810 6356 5874 2 AOI22X2_HS $T=1237400 328440 1 0 $X=1237220 $Y=323995
X49823 VSS: 2 VSS: 6983 7452 4536 5860 2 DFFX4_HS $T=1233260 336720 1 0 $X=1233080 $Y=332275
X49825 VSS: 2 VSS: 6988 6987 6985 5500 5503 2 AOI22X1_HS $T=1235100 336720 1 180 $X=1231700 $Y=336455
X49830 VSS: 2 VSS: 6986 6668 6815 3790 3810 2 AOI22X2_HS $T=1250280 336720 1 180 $X=1244580 $Y=336455
X49835 VSS: 2 VSS: 6984 3534 2 BUFX16_HS $T=1238780 345000 1 0 $X=1238600 $Y=340555
X49838 VSS: 2 VSS: 6991 6966 6823 6988 6989 2 NAND4X2_HS $T=1234640 345000 0 0 $X=1234460 $Y=344735
X49843 VSS: 2 VSS: 6993 6961 6987 6985 3855 2 AOI22X2_HS $T=1233720 353280 1 0 $X=1233540 $Y=348835
X49846 VSS: 2 VSS: 6990 5016 2 CLKBUFX4 $T=1244760 353280 0 180 $X=1241820 $Y=348835
X49850 VSS: 2 VSS: 6832 6985 2006 2007 6994 2 AOI22X1 $T=1237400 353280 1 180 $X=1234460 $Y=353015
X49854 VSS: 2 VSS: 6906 4657 2 BUFX16_HS $T=1250740 353280 1 180 $X=1240440 $Y=353015
X49858 VSS: 2 VSS: 6996 6528 6991 2 NOR2X2_HS $T=1239240 361560 0 180 $X=1235840 $Y=357115
X49863 VSS: 2 VSS: 6994 7453 4504 5860 2 DFFX4_HS $T=1231420 361560 0 0 $X=1231240 $Y=361295
X49864 VSS: 2 VSS: 7127 8154 5258 5018 2 DFFX1_HS $T=1242920 361560 0 0 $X=1242740 $Y=361295
X49867 VSS: 2 VSS: 6995 6826 6997 2 NAND2X2_HS $T=1231880 369840 1 0 $X=1231700 $Y=365395
X49877 VSS: 2 VSS: 7130 6667 6394 4929 960 2 AOI22X2_HS $T=1245220 369840 0 0 $X=1245040 $Y=369575
X49880 VSS: 2 VSS: 6997 6680 6999 2 NOR2X2_HS $T=1230500 378120 1 0 $X=1230320 $Y=373675
X49883 VSS: 2 VSS: 6998 5787 6830 6533 5874 2 AOI22X2_HS $T=1237860 378120 1 0 $X=1237680 $Y=373675
X49890 VSS: 2 VSS: 7001 7000 7003 7002 7004 2 NAND4X2_HS $T=1236940 386400 1 0 $X=1236760 $Y=381955
X49893 VSS: 2 VSS: 7005 6685 7001 2 NOR2X2_HS $T=1233720 386400 0 0 $X=1233540 $Y=386135
X49895 VSS: 2 VSS: 7006 7005 6996 2 NAND2X2_HS $T=1237860 386400 0 0 $X=1237680 $Y=386135
X49898 VSS: 2 VSS: 7135 4296 2 BUFX2_HS $T=1245220 386400 0 0 $X=1245040 $Y=386135
X49903 VSS: 2 VSS: 7002 7007 7008 6533 6830 2 AOI22X2 $T=1237860 394680 1 0 $X=1237680 $Y=390235
X49907 VSS: 2 VSS: 7007 5025 2 BUFX8 $T=1234640 394680 0 0 $X=1234460 $Y=394415
X49910 VSS: 2 VSS: 7008 5026 2 BUFX2_HS $T=1247060 394680 1 180 $X=1244120 $Y=394415
X49918 VSS: 2 VSS: 7009 6844 6385 7008 7007 2 AOI22X1_HS $T=1234640 402960 0 0 $X=1234460 $Y=402695
X49938 VSS: 2 VSS: 6961 3313 2 BUFX8_HS $T=1236940 419520 0 0 $X=1236760 $Y=419255
X49944 VSS: 2 VSS: 7010 5787 6844 6385 7011 2 AOI22X2_HS $T=1238320 427800 1 0 $X=1238140 $Y=423355
X49948 VSS: 2 VSS: 6842 6407 2006 2007 7012 2 AOI22X1 $T=1237860 427800 1 180 $X=1234920 $Y=427535
X49954 VSS: 2 VSS: 7012 8155 5258 5860 2 DFFX1_HS $T=1233720 436080 1 0 $X=1233540 $Y=431635
X49960 VSS: 2 VSS: 7015 3855 6407 7013 6961 2 AOI22X2 $T=1240620 436080 1 180 $X=1235840 $Y=435815
X49964 VSS: 2 VSS: 6847 7017 7015 7016 6848 2 NAND4X2_HS $T=1236480 444360 0 180 $X=1230780 $Y=439915
X49967 VSS: 2 VSS: 7123 7454 4504 5053 2 DFFX4_HS $T=1238780 444360 1 0 $X=1238600 $Y=439915
X49970 VSS: 2 VSS: 7014 8156 5258 5053 2 DFFX1_HS $T=1234180 444360 0 0 $X=1234000 $Y=444095
X49973 VSS: 2 VSS: 7020 5190 6407 7013 7019 2 AOI22X2_HS $T=1239240 452640 0 180 $X=1233540 $Y=448195
X49976 VSS: 2 VSS: 7017 4657 7014 7127 5538 2 AOI22X2 $T=1249360 452640 0 180 $X=1244580 $Y=448195
X49982 VSS: 2 VSS: 7019 5144 2 CLKBUFX2_HS $T=1235560 460920 1 0 $X=1235380 $Y=456475
X49985 VSS: 2 VSS: 2687 7021 2 BUFX16_HS $T=1243380 460920 1 0 $X=1243200 $Y=456475
X49987 VSS: 2 VSS: 7016 5294 6409 6264 3756 2 AOI22X2_HS $T=1230500 460920 0 0 $X=1230320 $Y=460655
X49990 VSS: 2 VSS: 7050 4914 2 BUFX16_HS $T=1240160 460920 0 0 $X=1239980 $Y=460655
X49994 VSS: 2 VSS: 7022 7023 6554 2 NOR2X2_HS $T=1240620 469200 0 180 $X=1237220 $Y=464755
X49999 VSS: 2 VSS: 7023 7026 7025 7024 6854 2 NAND4X4_HS $T=1242920 469200 1 180 $X=1234000 $Y=468935
X50001 VSS: 2 VSS: 7043 5016 2 BUFX8_HS $T=1243840 469200 0 0 $X=1243660 $Y=468935
X50002 VSS: 2 VSS: 7026 7027 5144 5190 6269 2 AOI22X1_HS $T=1229120 477480 1 0 $X=1228940 $Y=473035
X50006 VSS: 2 VSS: 6709 7455 4883 5618 2 DFFX4_HS $T=1241540 477480 1 0 $X=1241360 $Y=473035
X50010 VSS: 2 VSS: 7030 4207 6269 7027 7028 2 AOI22X2_HS $T=1240160 477480 1 180 $X=1234460 $Y=477215
X50013 VSS: 2 VSS: 7025 3620 6258 7029 7043 2 AOI22X2_HS $T=1242460 477480 0 0 $X=1242280 $Y=477215
X50014 VSS: 2 VSS: 6858 7031 7032 7030 6855 2 NAND4X2_HS $T=1229580 485760 1 0 $X=1229400 $Y=481315
X50018 VSS: 2 VSS: 7040 7456 4883 6936 2 DFFX4_HS $T=1243380 485760 1 0 $X=1243200 $Y=481315
X50022 VSS: 2 VSS: 7032 4657 7029 6258 5538 2 AOI22X2 $T=1246600 485760 1 180 $X=1241820 $Y=485495
X50024 VSS: 2 VSS: 7033 7457 4880 5860 2 DFFX4_HS $T=1233260 494040 1 0 $X=1233080 $Y=489595
X50026 VSS: 2 VSS: 6861 6269 2006 2007 7033 2 AOI22X1 $T=1232800 494040 1 180 $X=1229860 $Y=493775
X50030 VSS: 2 VSS: 7034 7458 4883 5860 2 DFFX4_HS $T=1236020 494040 0 0 $X=1235840 $Y=493775
X50033 VSS: 2 VSS: 7024 6056 6268 6411 7035 2 AOI22X2_HS $T=1239700 502320 0 180 $X=1234000 $Y=497875
X50038 VSS: 2 VSS: 7029 7459 4880 5053 2 DFFX4_HS $T=1238780 502320 0 0 $X=1238600 $Y=502055
X50040 VSS: 2 VSS: 6851 6056 6264 6409 7035 2 AOI22X2 $T=1235560 510600 0 180 $X=1230780 $Y=506155
X50045 VSS: 2 VSS: 6867 7038 7039 7036 7037 2 NAND4X4_HS $T=1231420 510600 0 0 $X=1231240 $Y=510335
X50050 VSS: 2 VSS: 7038 6059 6414 4971 4617 2 AOI22X2 $T=1238320 518880 0 180 $X=1233540 $Y=514435
X50058 VSS: 2 VSS: 7037 5787 6868 6567 7011 2 AOI22X2_HS $T=1239240 527160 0 180 $X=1233540 $Y=522715
X50063 VSS: 2 VSS: 7028 3313 2 BUFX8 $T=1234640 527160 0 0 $X=1234460 $Y=526895
X50066 VSS: 2 VSS: 7042 7035 6412 6270 6056 2 AOI22X1_HS $T=1232800 535440 0 180 $X=1229400 $Y=530995
X50069 VSS: 2 VSS: 7041 3855 6416 7040 7028 2 AOI22X2_HS $T=1239700 535440 0 180 $X=1234000 $Y=530995
X50070 VSS: 2 VSS: 7044 7460 4883 5053 2 DFFX4_HS $T=1239700 535440 1 0 $X=1239520 $Y=530995
X50073 VSS: 2 VSS: 7045 7040 5144 5190 6416 2 AOI22X1 $T=1235100 535440 0 0 $X=1234920 $Y=535175
X50077 VSS: 2 VSS: 7046 7043 7044 6266 3620 2 AOI22X1_HS $T=1242920 535440 0 0 $X=1242740 $Y=535175
X50080 VSS: 2 VSS: 7047 7041 7048 6872 7049 2 NAND4X2_HS $T=1235560 543720 1 0 $X=1235380 $Y=539275
X50083 VSS: 2 VSS: 7048 4657 7044 6266 5538 2 AOI22X2 $T=1247060 543720 0 180 $X=1242280 $Y=539275
X50099 VSS: 2 VSS: 6877 6416 2006 2007 7034 2 AOI22X1 $T=1233720 560280 0 180 $X=1230780 $Y=555835
X50103 VSS: 2 VSS: 7169 6160 6274 6064 7050 2 AOI22X2 $T=1241540 560280 1 0 $X=1241360 $Y=555835
X50110 VSS: 2 VSS: 7051 6578 6879 6884 2 NOR3X1 $T=1229580 568560 1 0 $X=1229400 $Y=564115
X50113 VSS: 2 VSS: 7011 3859 2 BUFX8_HS $T=1236020 568560 1 0 $X=1235840 $Y=564115
X50118 VSS: 2 VSS: 6883 6726 7047 2 NOR2X2_HS $T=1232340 568560 0 0 $X=1232160 $Y=568295
X50123 VSS: 2 VSS: 7173 6415 6874 5787 7011 2 AOI22X2_HS $T=1245220 568560 0 0 $X=1245040 $Y=568295
X50129 VSS: 2 VSS: 7053 4617 6064 6274 4929 2 AOI22X2 $T=1240620 576840 1 0 $X=1240440 $Y=572395
X50141 VSS: 2 VSS: 7054 7175 7174 7053 7173 2 NAND4X2_HS $T=1245220 585120 1 0 $X=1245040 $Y=580675
X50160 VSS: 2 VSS: 7136 1690 2 BUFX16_HS $T=1244760 601680 1 0 $X=1244580 $Y=597235
X50168 VSS: 2 VSS: 6886 5104 2 BUFX2_HS $T=1244760 609960 0 180 $X=1241820 $Y=605515
X50172 VSS: 2 VSS: 5821 4072 2 INVX8_HS $T=1235560 609960 0 0 $X=1235380 $Y=609695
X50180 VSS: 2 VSS: 7055 4987 6731 6174 4986 2 AOI22X2_HS $T=1230500 618240 0 0 $X=1230320 $Y=617975
X50231 VSS: 2 VSS: 7057 5817 6300 6742 3721 2 AOI22X1 $T=1246600 22080 0 0 $X=1246420 $Y=21815
X50239 VSS: 2 VSS: 7059 3790 6742 6300 3810 2 AOI22X2_HS $T=1245680 30360 1 0 $X=1245500 $Y=25915
X50307 VSS: 2 VSS: 7064 6199 2991 2992 7063 2 AOI22X1 $T=1256260 63480 0 0 $X=1256080 $Y=63215
X50316 VSS: 2 VSS: 7066 6200 2991 2992 6910 2 AOI22X1 $T=1257640 71760 1 0 $X=1257460 $Y=67315
X50325 VSS: 2 VSS: rdata_o[26] 7067 6748 7066 7068 2 NAND4X1 $T=1257640 71760 0 0 $X=1257460 $Y=71495
X50332 VSS: 2 VSS: 6914 5287 6907 7063 6944 2 AOI22X2_HS $T=1249360 80040 1 0 $X=1249180 $Y=75595
X50341 VSS: 2 VSS: 7068 7062 7070 2568 2 AOI21X1 $T=1257180 80040 0 0 $X=1257000 $Y=79775
X50348 VSS: 2 VSS: 7070 7073 5281 2 NAND2X1 $T=1247980 88320 1 0 $X=1247800 $Y=83875
X50350 VSS: 2 VSS: 7071 6901 6918 2568 2 AOI21X1 $T=1253500 88320 1 0 $X=1253320 $Y=83875
X50354 VSS: 2 VSS: rdata_o[17] 7072 6452 7064 7071 2 NAND4X1 $T=1259020 88320 1 0 $X=1258840 $Y=83875
X50362 VSS: 2 VSS: 7067 6599 2785 2796 6771 2 AOI22X1 $T=1258100 88320 0 0 $X=1257920 $Y=88055
X50367 VSS: 2 VSS: 6917 6908 2312 2311 6907 2 AOI22X1 $T=1247060 96600 1 0 $X=1246880 $Y=92155
X50372 VSS: 2 VSS: 7072 6594 2785 2796 6920 2 AOI22X1 $T=1258560 96600 1 0 $X=1258380 $Y=92155
X50379 VSS: 2 VSS: 7073 6912 2312 2311 7065 2 AOI22X1 $T=1246600 96600 0 0 $X=1246420 $Y=96335
X50389 VSS: 2 VSS: 6921 5287 6926 6922 6944 2 AOI22X2_HS $T=1248900 104880 1 0 $X=1248720 $Y=100435
X50399 VSS: 2 VSS: 7075 6206 2991 2992 6922 2 AOI22X1 $T=1259020 104880 0 0 $X=1258840 $Y=104615
X50405 VSS: 2 VSS: 7078 6615 7076 2568 2 AOI21X1 $T=1249820 113160 1 0 $X=1249640 $Y=108715
X50409 VSS: 2 VSS: rdata_o[22] 7077 6467 7075 7078 2 NAND4X1 $T=1260400 113160 1 0 $X=1260220 $Y=108715
X50414 VSS: 2 VSS: 7079 6768 2312 2311 6926 2 AOI22X1 $T=1247060 113160 0 0 $X=1246880 $Y=112895
X50423 VSS: 2 VSS: 7076 7079 5289 2 NAND2X1 $T=1250280 121440 1 0 $X=1250100 $Y=116995
X50425 VSS: 2 VSS: 6907 7461 4461 5018 2 DFFX4_HS $T=1253960 121440 1 0 $X=1253780 $Y=116995
X50434 VSS: 2 VSS: 7077 6602 2785 2796 6927 2 AOI22X1 $T=1259020 121440 0 0 $X=1258840 $Y=121175
X50438 VSS: 2 VSS: 6922 7462 4396 5714 2 DFFX4_HS $T=1254420 129720 1 0 $X=1254240 $Y=125275
X50443 VSS: 2 VSS: 6910 8157 4463 5714 2 DFFX1_HS $T=1255800 129720 0 0 $X=1255620 $Y=129455
X50448 VSS: 2 VSS: 7062 8158 4463 6928 2 DFFX1_HS $T=1255340 138000 1 0 $X=1255160 $Y=133555
X50453 VSS: 2 VSS: 6901 7463 4461 6928 2 DFFX4_HS $T=1254420 138000 0 0 $X=1254240 $Y=137735
X50457 VSS: 2 VSS: 7081 6775 7080 2568 2 AOI21X1 $T=1247980 146280 1 0 $X=1247800 $Y=141835
X50462 VSS: 2 VSS: 7082 6209 2785 2796 6932 2 AOI22X1 $T=1259020 146280 1 0 $X=1258840 $Y=141835
X50469 VSS: 2 VSS: rdata_o[31] 7082 6322 7083 7081 2 NAND4X1 $T=1259020 146280 0 0 $X=1258840 $Y=146015
X50475 VSS: 2 VSS: 7080 7085 5374 2 NAND2X1 $T=1248440 154560 1 0 $X=1248260 $Y=150115
X50480 VSS: 2 VSS: 7083 6110 2991 2992 6938 2 AOI22X1 $T=1259020 154560 1 0 $X=1258840 $Y=150115
X50484 VSS: 2 VSS: 6920 7464 4461 6936 2 DFFX4_HS $T=1256260 154560 0 0 $X=1256080 $Y=154295
X50489 VSS: 2 VSS: 6771 8159 4463 6936 2 DFFX1_HS $T=1256260 162840 1 0 $X=1256080 $Y=158395
X50496 VSS: 2 VSS: 6602 7465 4396 5446 2 DFFX4_HS $T=1253960 162840 0 0 $X=1253780 $Y=162575
X50504 VSS: 2 VSS: 6594 7466 4461 5446 2 DFFX4_HS $T=1254880 171120 1 0 $X=1254700 $Y=166675
X50512 VSS: 2 VSS: 6599 8160 4463 5446 2 DFFX1_HS $T=1256260 171120 0 0 $X=1256080 $Y=170855
X50516 VSS: 2 VSS: 7085 6933 2312 2311 7086 2 AOI22X1 $T=1248440 179400 0 180 $X=1245500 $Y=174955
X50521 VSS: 2 VSS: 6209 7467 4530 5446 2 DFFX4_HS $T=1255340 179400 1 0 $X=1255160 $Y=174955
X50528 VSS: 2 VSS: 6938 7468 4530 5714 2 DFFX4_HS $T=1254420 179400 0 0 $X=1254240 $Y=179135
X50534 VSS: 2 VSS: 7088 6120 2991 2992 7087 2 AOI22X1 $T=1253040 187680 1 0 $X=1252860 $Y=183235
X50543 VSS: 2 VSS: 7087 8161 4331 5714 2 DFFX1_HS $T=1254420 187680 0 0 $X=1254240 $Y=187415
X50549 VSS: 2 VSS: 6947 8162 4331 6936 2 DFFX1_HS $T=1255340 195960 1 0 $X=1255160 $Y=191515
X50556 VSS: 2 VSS: rdata_o[27] 7089 6488 7088 7090 2 NAND4X1 $T=1253500 195960 0 0 $X=1253320 $Y=195695
X50559 VSS: 2 VSS: 7089 6124 2785 2796 6947 2 AOI22X1 $T=1258560 195960 0 0 $X=1258380 $Y=195695
X50567 VSS: 2 VSS: 7092 6949 4612 2 NAND2X1 $T=1251200 204240 1 0 $X=1251020 $Y=199795
X50570 VSS: 2 VSS: 7090 6780 7092 2568 2 AOI21X1 $T=1259480 204240 0 180 $X=1257000 $Y=199795
X50577 VSS: 2 VSS: 6124 7469 4331 5446 2 DFFX4_HS $T=1254880 204240 0 0 $X=1254700 $Y=203975
X50583 VSS: 2 VSS: 6780 7470 4331 6928 2 DFFX4_HS $T=1254420 212520 1 0 $X=1254240 $Y=208075
X50596 VSS: 2 VSS: 7094 7471 4920 5714 2 DFFX4_HS $T=1253040 220800 1 0 $X=1252860 $Y=216355
X50601 VSS: 2 VSS: 6954 6944 7094 7093 6974 2 AOI22X2_HS $T=1247980 220800 0 0 $X=1247800 $Y=220535
X50603 VSS: 2 VSS: 7093 7472 4920 5018 2 DFFX4_HS $T=1253960 220800 0 0 $X=1253780 $Y=220535
X50609 VSS: 2 VSS: 7095 6950 2312 2311 7093 2 AOI22X1 $T=1250740 229080 0 180 $X=1247800 $Y=224635
X50613 VSS: 2 VSS: 7096 7095 5257 2 NAND2X1 $T=1257180 229080 1 0 $X=1257000 $Y=224635
X50620 VSS: 2 VSS: 6959 7473 4920 6936 2 DFFX4_HS $T=1254420 229080 0 0 $X=1254240 $Y=228815
X50628 VSS: 2 VSS: 7098 7097 7096 2568 2 AOI21X1 $T=1257640 237360 1 0 $X=1257460 $Y=232915
X50635 VSS: 2 VSS: 7100 6223 2991 2992 7094 2 AOI22X1 $T=1248440 237360 0 0 $X=1248260 $Y=237095
X50638 VSS: 2 VSS: rdata_o[19] 7099 6797 7100 7098 2 NAND4X1 $T=1258560 237360 0 0 $X=1258380 $Y=237095
X50646 VSS: 2 VSS: 7099 6647 2785 2796 6959 2 AOI22X1 $T=1258560 245640 1 0 $X=1258380 $Y=241195
X50661 VSS: 2 VSS: 7097 7474 4920 6928 2 DFFX4_HS $T=1254420 253920 1 0 $X=1254240 $Y=249475
X50676 VSS: 2 VSS: 6647 7475 4920 5446 2 DFFX4_HS $T=1255340 262200 1 0 $X=1255160 $Y=257755
X50680 VSS: 2 VSS: 7103 6344 6802 3790 3810 2 AOI22X2 $T=1246140 262200 0 0 $X=1245960 $Y=261935
X50687 VSS: 2 VSS: 7105 5984 6649 6508 7050 2 AOI22X2_HS $T=1245680 270480 1 0 $X=1245500 $Y=266035
X50694 VSS: 2 VSS: 6964 5817 6344 6802 4986 2 AOI22X1 $T=1246140 270480 0 0 $X=1245960 $Y=270215
X50710 VSS: 2 VSS: 6974 5256 2 BUFX8_HS $T=1246600 278760 0 0 $X=1246420 $Y=278495
X50713 VSS: 2 VSS: 7109 7476 4536 5714 2 DFFX4_HS $T=1253500 278760 0 0 $X=1253320 $Y=278495
X50718 VSS: 2 VSS: 7107 6965 2312 2311 7106 2 AOI22X1 $T=1249820 287040 0 180 $X=1246880 $Y=282595
X50721 VSS: 2 VSS: 7106 7477 4536 5018 2 DFFX4_HS $T=1253960 287040 1 0 $X=1253780 $Y=282595
X50729 VSS: 2 VSS: 7108 7107 4789 2 NAND2X1 $T=1248900 287040 0 0 $X=1248720 $Y=286775
X50733 VSS: 2 VSS: 6978 7478 4536 6936 2 DFFX4_HS $T=1253960 287040 0 0 $X=1253780 $Y=286775
X50737 VSS: 2 VSS: 6976 7109 7106 6974 6972 2 AOI22X1_HS $T=1251660 295320 0 180 $X=1248260 $Y=290875
X50740 VSS: 2 VSS: 6658 7479 4536 5446 2 DFFX4_HS $T=1254420 295320 1 0 $X=1254240 $Y=290875
X50747 VSS: 2 VSS: 7110 6224 2991 2992 7109 2 AOI22X1 $T=1256260 295320 0 0 $X=1256080 $Y=295055
X50754 VSS: 2 VSS: 6970 7111 7112 7113 2 NAND3X2_HS $T=1251200 303600 0 180 $X=1246420 $Y=299155
X50759 VSS: 2 VSS: 7114 6658 2785 2796 6978 2 AOI22X1 $T=1258100 303600 1 0 $X=1257920 $Y=299155
X50765 VSS: 2 VSS: 7111 6981 7115 2 AND2X1_HS $T=1255340 303600 1 180 $X=1252400 $Y=303335
X50772 VSS: 2 VSS: 7113 5984 7050 6514 6659 2 AOI22X2 $T=1246140 311880 1 0 $X=1245960 $Y=307435
X50783 VSS: 2 VSS: 7119 7116 7108 2568 2 AOI21X1 $T=1258100 311880 0 0 $X=1257920 $Y=311615
X50791 VSS: 2 VSS: rdata_o[20] 7114 6812 7110 7119 2 NAND4X1 $T=1257640 320160 1 0 $X=1257460 $Y=315715
X50796 VSS: 2 VSS: 7117 4929 6659 6514 4660 2 AOI22X1_HS $T=1249360 320160 1 180 $X=1245960 $Y=319895
X50804 VSS: 2 VSS: 7112 6984 6613 6983 7116 2 AOI22X2_HS $T=1246600 328440 1 0 $X=1246420 $Y=323995
X50807 VSS: 2 VSS: 7116 7480 4536 6928 2 DFFX4_HS $T=1254420 328440 1 0 $X=1254240 $Y=323995
X50813 VSS: 2 VSS: 7115 5817 6668 6815 4986 2 AOI22X1 $T=1249360 328440 0 0 $X=1249180 $Y=328175
X50836 VSS: 2 VSS: 7122 6816 2312 2311 7121 2 AOI22X1 $T=1250740 345000 1 0 $X=1250560 $Y=340555
X50838 VSS: 2 VSS: 7121 7481 4504 5018 2 DFFX4_HS $T=1254420 345000 1 0 $X=1254240 $Y=340555
X50843 VSS: 2 VSS: 6989 7123 7121 6974 6990 2 AOI22X1_HS $T=1249820 345000 1 180 $X=1246420 $Y=344735
X50848 VSS: 2 VSS: 7124 7122 4295 2 NAND2X1 $T=1256720 345000 0 0 $X=1256540 $Y=344735
X50855 VSS: 2 VSS: 6992 6906 7123 7121 5538 2 AOI22X2 $T=1252580 353280 0 180 $X=1247800 $Y=348835
X50858 VSS: 2 VSS: 6987 7482 4504 6936 2 DFFX4_HS $T=1253960 353280 1 0 $X=1253780 $Y=348835
X50864 VSS: 2 VSS: 7125 7483 4504 6928 2 DFFX4_HS $T=1253040 353280 0 0 $X=1252860 $Y=353015
X50868 VSS: 2 VSS: 7000 6613 6994 7125 6984 2 AOI22X2_HS $T=1252120 361560 0 180 $X=1246420 $Y=357115
X50872 VSS: 2 VSS: 7126 7125 7124 2568 2 AOI21X1 $T=1257180 361560 1 0 $X=1257000 $Y=357115
X50878 VSS: 2 VSS: 6682 7484 4504 5446 2 DFFX4_HS $T=1253960 361560 0 0 $X=1253780 $Y=361295
X50884 VSS: 2 VSS: 7128 4927 7125 6994 3497 2 AOI22X2 $T=1247520 369840 1 0 $X=1247340 $Y=365395
X50888 VSS: 2 VSS: 7129 6682 2785 2796 6987 2 AOI22X1 $T=1258560 369840 1 0 $X=1258380 $Y=365395
X50894 VSS: 2 VSS: 6928 5584 2 CLKBUFX8 $T=1250740 369840 0 0 $X=1250560 $Y=369575
X50901 VSS: 2 VSS: 6999 7130 7132 7128 6998 2 NAND4X2_HS $T=1247980 378120 1 0 $X=1247800 $Y=373675
X50904 VSS: 2 VSS: rdata_o[28] 7129 6827 7131 7126 2 NAND4X1 $T=1258100 378120 1 0 $X=1257920 $Y=373675
X50911 VSS: 2 VSS: 7004 6160 6394 6667 7050 2 AOI22X2_HS $T=1246600 378120 0 0 $X=1246420 $Y=377855
X50920 VSS: 2 VSS: 7003 4986 6817 6679 7134 2 AOI22X2_HS $T=1248440 386400 1 0 $X=1248260 $Y=381955
X50930 VSS: 2 VSS: 7134 4987 2 BUFX16_HS $T=1251200 386400 0 0 $X=1251020 $Y=386135
X50937 VSS: 2 VSS: 7132 7136 6679 6817 7135 2 AOI22X2_HS $T=1253960 394680 0 180 $X=1248260 $Y=390235
X50951 VSS: 2 VSS: 7137 6160 7050 6669 6393 2 AOI22X2 $T=1246600 402960 1 0 $X=1246420 $Y=398515
X50959 VSS: 2 VSS: 6834 7138 7009 7139 7137 2 NAND4X1_HS $T=1249820 402960 1 180 $X=1246420 $Y=402695
X50963 VSS: 2 VSS: 7131 6255 2991 2992 7123 2 AOI22X1 $T=1257640 402960 0 0 $X=1257460 $Y=402695
X50970 VSS: 2 VSS: 7138 4986 6821 6692 7134 2 AOI22X2 $T=1252580 411240 0 180 $X=1247800 $Y=406795
X50979 VSS: 2 VSS: 7140 7136 6692 6821 3790 2 AOI22X1_HS $T=1252120 411240 1 180 $X=1248720 $Y=410975
X50988 VSS: 2 VSS: 7141 960 4929 6393 6669 2 AOI22X1_HS $T=1247520 419520 1 0 $X=1247340 $Y=415075
X50996 VSS: 2 VSS: 6841 7141 7142 7140 7010 2 NAND4X2_HS $T=1251660 419520 1 180 $X=1245960 $Y=419255
X50998 VSS: 2 VSS: 6690 8163 5258 5446 2 DFFX1_HS $T=1255340 419520 0 0 $X=1255160 $Y=419255
X51004 VSS: 2 VSS: 7013 8164 5258 6936 2 DFFX1_HS $T=1252120 427800 1 0 $X=1251940 $Y=423355
X51010 VSS: 2 VSS: 7142 3497 7012 7143 4927 2 AOI22X1_HS $T=1247980 427800 0 0 $X=1247800 $Y=427535
X51014 VSS: 2 VSS: 7144 6690 2785 2796 7013 2 AOI22X1 $T=1259480 427800 0 0 $X=1259300 $Y=427535
X51019 VSS: 2 VSS: 7139 6984 3496 7012 7143 2 AOI22X2_HS $T=1246140 436080 1 0 $X=1245960 $Y=431635
X51023 VSS: 2 VSS: 7143 8165 5258 6928 2 DFFX1_HS $T=1254880 436080 1 0 $X=1254700 $Y=431635
X51028 VSS: 2 VSS: 7146 6256 2991 2992 7014 2 AOI22X1 $T=1248440 436080 0 0 $X=1248260 $Y=435815
X51033 VSS: 2 VSS: rdata_o[15] 7144 6846 7146 7145 2 NAND4X1 $T=1259940 436080 0 0 $X=1259760 $Y=435815
X51039 VSS: 2 VSS: 7145 7143 7147 2568 2 AOI21X1 $T=1259940 444360 0 180 $X=1257460 $Y=439915
X51045 VSS: 2 VSS: 7018 6990 3620 7127 7014 2 AOI22X2 $T=1251200 444360 1 180 $X=1246420 $Y=444095
X51049 VSS: 2 VSS: 7147 7148 4464 2 NAND2X1 $T=1257180 444360 0 0 $X=1257000 $Y=444095
X51058 VSS: 2 VSS: 7148 6409 2312 2311 7127 2 AOI22X1 $T=1255800 452640 1 0 $X=1255620 $Y=448195
X51086 VSS: 2 VSS: 7021 7149 7022 2 NAND2X2_HS $T=1250280 469200 0 180 $X=1246880 $Y=464755
X51090 VSS: 2 VSS: 7155 7485 4880 6928 2 DFFX4_HS $T=1253500 469200 1 0 $X=1253320 $Y=464755
X51096 VSS: 2 VSS: 6857 7486 4880 5618 2 DFFX4_HS $T=1253500 469200 0 0 $X=1253320 $Y=468935
X51101 VSS: 2 VSS: 7027 7487 4880 6936 2 DFFX4_HS $T=1253960 477480 1 0 $X=1253780 $Y=473035
X51107 VSS: 2 VSS: 7150 7488 4883 6928 2 DFFX4_HS $T=1250740 477480 0 0 $X=1250560 $Y=477215
X51113 VSS: 2 VSS: 7151 6857 2785 2796 7027 2 AOI22X1 $T=1259020 485760 1 0 $X=1258840 $Y=481315
X51120 VSS: 2 VSS: 7152 6709 2785 2796 7040 2 AOI22X1 $T=1254880 485760 0 0 $X=1254700 $Y=485495
X51129 VSS: 2 VSS: 7154 7153 4743 2 NAND2X1 $T=1249820 494040 0 180 $X=1247800 $Y=489595
X51132 VSS: 2 VSS: 7153 6411 2312 2311 6258 2 AOI22X1 $T=1255340 494040 1 0 $X=1255160 $Y=489595
X51142 VSS: 2 VSS: 7156 7155 7154 2568 2 AOI21X1 $T=1258100 494040 0 0 $X=1257920 $Y=493775
X51148 VSS: 2 VSS: 7149 6715 7159 2 NOR2X2_HS $T=1247060 502320 1 0 $X=1246880 $Y=497875
X51152 VSS: 2 VSS: rdata_o[24] 7151 6713 7158 7156 2 NAND4X1 $T=1258560 502320 1 0 $X=1258380 $Y=497875
X51167 VSS: 2 VSS: 7158 6260 2991 2992 7029 2 AOI22X1 $T=1249820 510600 1 0 $X=1249640 $Y=506155
X51175 VSS: 2 VSS: 7036 3497 7033 7155 4927 2 AOI22X2 $T=1253040 510600 1 180 $X=1248260 $Y=510335
X51185 VSS: 2 VSS: 7160 3496 7033 7155 6984 2 AOI22X2_HS $T=1259020 518880 0 180 $X=1253320 $Y=514435
X51191 VSS: 2 VSS: 7159 7160 7163 7162 7161 2 NAND4X2_HS $T=1252580 518880 1 180 $X=1246880 $Y=518615
X51199 VSS: 2 VSS: 7163 5026 6567 6868 7007 2 AOI22X2_HS $T=1247060 527160 1 0 $X=1246880 $Y=522715
X51209 VSS: 2 VSS: 7164 6412 2312 2311 6266 2 AOI22X1 $T=1254420 527160 0 0 $X=1254240 $Y=526895
X51217 VSS: 2 VSS: 7165 7164 4835 2 NAND2X1 $T=1255800 535440 1 0 $X=1255620 $Y=530995
X51224 VSS: 2 VSS: 7166 6267 2991 2992 7044 2 AOI22X1 $T=1249820 535440 0 0 $X=1249640 $Y=535175
X51228 VSS: 2 VSS: 7167 7150 7165 2568 2 AOI21X1 $T=1258100 535440 1 180 $X=1255620 $Y=535175
X51237 VSS: 2 VSS: rdata_o[29] 7152 7051 7166 7167 2 NAND4X1 $T=1254880 543720 1 0 $X=1254700 $Y=539275
X51244 VSS: 2 VSS: 7161 6160 6414 6059 7050 2 AOI22X2_HS $T=1246600 543720 0 0 $X=1246420 $Y=543455
X51252 VSS: 2 VSS: 7039 4296 6272 6871 7136 2 AOI22X2_HS $T=1246140 552000 1 0 $X=1245960 $Y=547555
X51260 VSS: 2 VSS: 7162 4986 6272 6871 7134 2 AOI22X2_HS $T=1246600 552000 0 0 $X=1246420 $Y=551735
X51270 VSS: 2 VSS: 7170 6984 3496 7034 7150 2 AOI22X2_HS $T=1253960 560280 1 0 $X=1253780 $Y=555835
X51276 VSS: 2 VSS: 7171 5026 6415 6874 7007 2 AOI22X2 $T=1250740 560280 1 180 $X=1245960 $Y=560015
X51283 VSS: 2 VSS: 6880 7171 7169 7170 7172 2 NAND4X2_HS $T=1245680 568560 1 0 $X=1245500 $Y=564115
X51306 VSS: 2 VSS: 7174 3497 7034 7150 4927 2 AOI22X1 $T=1250280 576840 1 180 $X=1247340 $Y=576575
X51320 VSS: 2 VSS: 7172 7134 6876 6277 4986 2 AOI22X1_HS $T=1250280 585120 1 180 $X=1246880 $Y=584855
X51328 VSS: 2 VSS: 7175 3790 6277 6876 7136 2 AOI22X2 $T=1251200 593400 0 180 $X=1246420 $Y=588955
M52762 22 24 VSS: VSS: nfet_01v8 L=1.5e-07 W=7.6e-07 $X=55600 $Y=395270 $dt=0
M52763 VSS: 24 22 VSS: nfet_01v8 L=1.5e-07 W=7.6e-07 $X=56030 $Y=395270 $dt=0
M52764 22 26 VSS: VSS: nfet_01v8 L=1.5e-07 W=7.6e-07 $X=56460 $Y=395270 $dt=0
M52765 VSS: 26 22 VSS: nfet_01v8 L=1.5e-07 W=7.6e-07 $X=56890 $Y=395270 $dt=0
M52766 21 25 22 VSS: nfet_01v8 L=1.5e-07 W=7.6e-07 $X=57840 $Y=395270 $dt=0
M52767 22 25 21 VSS: nfet_01v8 L=1.5e-07 W=7.6e-07 $X=58270 $Y=395270 $dt=0
M52768 21 27 23 VSS: nfet_01v8 L=1.5e-07 W=7.6e-07 $X=58700 $Y=395270 $dt=0
M52769 23 27 21 VSS: nfet_01v8 L=1.5e-07 W=7.6e-07 $X=59130 $Y=395270 $dt=0
M52770 VSS: 31 8186 VSS: nfet_01v8 L=1.5e-07 W=4.25e-07 $X=76760 $Y=353870 $dt=0
M52771 8186 33 8187 VSS: nfet_01v8 L=1.5e-07 W=4.25e-07 $X=77190 $Y=353870 $dt=0
M52772 8187 32 29 VSS: nfet_01v8 L=1.5e-07 W=4.25e-07 $X=77620 $Y=353870 $dt=0
M52773 VSS: 29 30 VSS: nfet_01v8 L=1.5e-07 W=7.6e-07 $X=78570 $Y=353870 $dt=0
M52774 56 57 VSS: VSS: nfet_01v8 L=1.5e-07 W=4.25e-07 $X=104360 $Y=327425 $dt=0
M52775 VSS: 58 53 VSS: nfet_01v8 L=1.5e-07 W=4.25e-07 $X=104790 $Y=327425 $dt=0
M52776 53 57 54 VSS: nfet_01v8 L=1.5e-07 W=4.25e-07 $X=105220 $Y=327425 $dt=0
M52777 54 56 8191 VSS: nfet_01v8 L=1.5e-07 W=4.25e-07 $X=105650 $Y=327425 $dt=0
M52778 VSS: 53 8191 VSS: nfet_01v8 L=1.5e-07 W=4.25e-07 $X=106080 $Y=327425 $dt=0
M52779 VSS: 54 55 VSS: nfet_01v8 L=1.5e-07 W=7.6e-07 $X=106570 $Y=327090 $dt=0
M52780 55 54 VSS: VSS: nfet_01v8 L=1.5e-07 W=7.6e-07 $X=107000 $Y=327090 $dt=0
M52781 74 71 VSS: VSS: nfet_01v8 L=1.5e-07 W=7.6e-07 $X=117240 $Y=169770 $dt=0
M52782 VSS: 71 74 VSS: nfet_01v8 L=1.5e-07 W=7.6e-07 $X=117670 $Y=169770 $dt=0
M52783 74 70 68 VSS: nfet_01v8 L=1.5e-07 W=7.6e-07 $X=118100 $Y=169770 $dt=0
M52784 68 70 74 VSS: nfet_01v8 L=1.5e-07 W=7.6e-07 $X=118530 $Y=169770 $dt=0
M52785 74 72 VSS: VSS: nfet_01v8 L=1.5e-07 W=7.6e-07 $X=119480 $Y=169770 $dt=0
M52786 VSS: 72 74 VSS: nfet_01v8 L=1.5e-07 W=7.6e-07 $X=119910 $Y=169770 $dt=0
M52787 74 73 68 VSS: nfet_01v8 L=1.5e-07 W=7.6e-07 $X=120340 $Y=169770 $dt=0
M52788 68 73 74 VSS: nfet_01v8 L=1.5e-07 W=7.6e-07 $X=120770 $Y=169770 $dt=0
M52789 66 63 VSS: VSS: nfet_01v8 L=1.5e-07 W=7.6e-07 $X=128280 $Y=144930 $dt=0
M52790 VSS: 63 66 VSS: nfet_01v8 L=1.5e-07 W=7.6e-07 $X=128710 $Y=144930 $dt=0
M52791 66 61 65 VSS: nfet_01v8 L=1.5e-07 W=7.6e-07 $X=129140 $Y=144930 $dt=0
M52792 65 61 66 VSS: nfet_01v8 L=1.5e-07 W=7.6e-07 $X=129570 $Y=144930 $dt=0
M52793 VSS: 64 65 VSS: nfet_01v8 L=1.5e-07 W=7.6e-07 $X=130520 $Y=144930 $dt=0
M52794 65 64 VSS: VSS: nfet_01v8 L=1.5e-07 W=7.6e-07 $X=130950 $Y=144930 $dt=0
M52795 VSS: 62 65 VSS: nfet_01v8 L=1.5e-07 W=7.6e-07 $X=131380 $Y=144930 $dt=0
M52796 65 62 VSS: VSS: nfet_01v8 L=1.5e-07 W=7.6e-07 $X=131810 $Y=144930 $dt=0
M52797 85 90 VSS: VSS: nfet_01v8 L=1.5e-07 W=4.25e-07 $X=143920 $Y=395270 $dt=0
M52798 VSS: 89 8192 VSS: nfet_01v8 L=1.5e-07 W=4.25e-07 $X=144350 $Y=395270 $dt=0
M52799 8192 85 86 VSS: nfet_01v8 L=1.5e-07 W=4.25e-07 $X=144780 $Y=395270 $dt=0
M52800 86 88 8193 VSS: nfet_01v8 L=1.5e-07 W=4.25e-07 $X=145210 $Y=395270 $dt=0
M52801 8193 87 VSS: VSS: nfet_01v8 L=1.5e-07 W=4.25e-07 $X=145640 $Y=395270 $dt=0
M52802 VSS: 85 88 VSS: nfet_01v8 L=1.5e-07 W=4.25e-07 $X=146070 $Y=395270 $dt=0
M52803 VSS: 86 87 VSS: nfet_01v8 L=1.5e-07 W=4.25e-07 $X=147020 $Y=395270 $dt=0
M52804 87 88 99 VSS: nfet_01v8 L=1.5e-07 W=4.25e-07 $X=147450 $Y=395270 $dt=0
M52805 99 85 8196 VSS: nfet_01v8 L=1.5e-07 W=4.25e-07 $X=147880 $Y=395270 $dt=0
M52806 8196 100 VSS: VSS: nfet_01v8 L=1.5e-07 W=4.25e-07 $X=148310 $Y=395270 $dt=0
M52807 VSS: 99 100 VSS: nfet_01v8 L=1.5e-07 W=6e-07 $X=148800 $Y=395270 $dt=0
M52808 100 99 VSS: VSS: nfet_01v8 L=1.5e-07 W=6e-07 $X=149230 $Y=395270 $dt=0
M52809 96 100 VSS: VSS: nfet_01v8 L=1.5e-07 W=7.6e-07 $X=150180 $Y=395270 $dt=0
M52810 VSS: 100 97 VSS: nfet_01v8 L=1.5e-07 W=7.6e-07 $X=150610 $Y=395270 $dt=0
M52811 97 100 VSS: VSS: nfet_01v8 L=1.5e-07 W=7.6e-07 $X=151040 $Y=395270 $dt=0
M52812 VSS: 100 97 VSS: nfet_01v8 L=1.5e-07 W=7.6e-07 $X=151470 $Y=395270 $dt=0
M52813 97 100 VSS: VSS: nfet_01v8 L=1.5e-07 W=7.6e-07 $X=151900 $Y=395270 $dt=0
M52814 VSS: 96 98 VSS: nfet_01v8 L=1.5e-07 W=7.6e-07 $X=152330 $Y=395270 $dt=0
M52815 98 96 VSS: VSS: nfet_01v8 L=1.5e-07 W=7.6e-07 $X=152760 $Y=395270 $dt=0
M52816 VSS: 96 98 VSS: nfet_01v8 L=1.5e-07 W=7.6e-07 $X=153190 $Y=395270 $dt=0
M52817 98 96 VSS: VSS: nfet_01v8 L=1.5e-07 W=7.6e-07 $X=153620 $Y=395270 $dt=0
M52818 92 95 8194 VSS: nfet_01v8 L=1.5e-07 W=4.25e-07 $X=160480 $Y=271070 $dt=0
M52819 8194 93 8195 VSS: nfet_01v8 L=1.5e-07 W=4.25e-07 $X=160910 $Y=271070 $dt=0
M52820 8195 94 VSS: VSS: nfet_01v8 L=1.5e-07 W=4.25e-07 $X=161340 $Y=271070 $dt=0
M52821 VSS: 92 91 VSS: nfet_01v8 L=1.5e-07 W=7.6e-07 $X=161830 $Y=271070 $dt=0
M52822 91 92 VSS: VSS: nfet_01v8 L=1.5e-07 W=7.6e-07 $X=162260 $Y=271070 $dt=0
M52823 128 136 VSS: VSS: nfet_01v8 L=1.5e-07 W=4.25e-07 $X=348160 $Y=105470 $dt=0
M52824 VSS: 134 8200 VSS: nfet_01v8 L=1.5e-07 W=4.25e-07 $X=348590 $Y=105470 $dt=0
M52825 8200 128 129 VSS: nfet_01v8 L=1.5e-07 W=4.25e-07 $X=349020 $Y=105470 $dt=0
M52826 129 130 8201 VSS: nfet_01v8 L=1.5e-07 W=4.25e-07 $X=349450 $Y=105470 $dt=0
M52827 8201 131 8202 VSS: nfet_01v8 L=1.5e-07 W=4.25e-07 $X=349880 $Y=105470 $dt=0
M52828 8202 135 VSS: VSS: nfet_01v8 L=1.5e-07 W=4.25e-07 $X=350310 $Y=105470 $dt=0
M52829 130 128 VSS: VSS: nfet_01v8 L=1.5e-07 W=4.25e-07 $X=351260 $Y=105470 $dt=0
M52830 VSS: 129 131 VSS: nfet_01v8 L=1.5e-07 W=4.25e-07 $X=351690 $Y=105470 $dt=0
M52831 131 130 132 VSS: nfet_01v8 L=1.5e-07 W=4.25e-07 $X=352120 $Y=105470 $dt=0
M52832 132 128 8203 VSS: nfet_01v8 L=1.5e-07 W=4.25e-07 $X=352550 $Y=105470 $dt=0
M52833 8203 133 VSS: VSS: nfet_01v8 L=1.5e-07 W=4.25e-07 $X=352980 $Y=105470 $dt=0
M52834 133 132 8204 VSS: nfet_01v8 L=1.5e-07 W=4.25e-07 $X=353930 $Y=105470 $dt=0
M52835 8204 135 VSS: VSS: nfet_01v8 L=1.5e-07 W=4.25e-07 $X=354360 $Y=105470 $dt=0
M52836 VSS: 133 125 VSS: nfet_01v8 L=1.5e-07 W=4.25e-07 $X=354790 $Y=105470 $dt=0
M52837 126 133 VSS: VSS: nfet_01v8 L=1.5e-07 W=7.6e-07 $X=355740 $Y=105470 $dt=0
M52838 VSS: 125 127 VSS: nfet_01v8 L=1.5e-07 W=7.6e-07 $X=356170 $Y=105470 $dt=0
M52839 9 16 12 2 pfet_01v8 L=1.5e-07 W=1.46e-06 $X=35540 $Y=399215 $dt=1
M52840 12 16 9 2 pfet_01v8 L=1.5e-07 W=1.46e-06 $X=35970 $Y=399215 $dt=1
M52841 9 13 2 2 pfet_01v8 L=1.5e-07 W=1.46e-06 $X=36400 $Y=399215 $dt=1
M52842 2 13 9 2 pfet_01v8 L=1.5e-07 W=1.46e-06 $X=36830 $Y=399215 $dt=1
M52843 10 17 12 2 pfet_01v8 L=1.5e-07 W=1.46e-06 $X=37780 $Y=399215 $dt=1
M52844 12 17 10 2 pfet_01v8 L=1.5e-07 W=1.46e-06 $X=38210 $Y=399215 $dt=1
M52845 10 14 2 2 pfet_01v8 L=1.5e-07 W=1.46e-06 $X=38640 $Y=399215 $dt=1
M52846 2 14 10 2 pfet_01v8 L=1.5e-07 W=1.46e-06 $X=39070 $Y=399215 $dt=1
M52847 11 18 12 2 pfet_01v8 L=1.5e-07 W=1.46e-06 $X=40020 $Y=399215 $dt=1
M52848 12 18 11 2 pfet_01v8 L=1.5e-07 W=1.46e-06 $X=40450 $Y=399215 $dt=1
M52849 11 15 2 2 pfet_01v8 L=1.5e-07 W=1.46e-06 $X=40880 $Y=399215 $dt=1
M52850 2 15 11 2 pfet_01v8 L=1.5e-07 W=1.46e-06 $X=41310 $Y=399215 $dt=1
M52851 2 7 3 2 pfet_01v8 L=1.5e-07 W=7.8e-07 $X=46860 $Y=241895 $dt=1
M52852 3 5 2 2 pfet_01v8 L=1.5e-07 W=7.8e-07 $X=47290 $Y=241895 $dt=1
M52853 2 8 3 2 pfet_01v8 L=1.5e-07 W=7.8e-07 $X=47720 $Y=241895 $dt=1
M52854 3 6 2 2 pfet_01v8 L=1.5e-07 W=7.8e-07 $X=48150 $Y=241895 $dt=1
M52855 2 3 4 2 pfet_01v8 L=1.5e-07 W=1.46e-06 $X=48640 $Y=241895 $dt=1
M52856 28 24 2 2 pfet_01v8 L=1.5e-07 W=1.13e-06 $X=55600 $Y=397100 $dt=1
M52857 2 24 28 2 pfet_01v8 L=1.5e-07 W=1.13e-06 $X=56030 $Y=397100 $dt=1
M52858 28 26 23 2 pfet_01v8 L=1.5e-07 W=1.13e-06 $X=56460 $Y=397100 $dt=1
M52859 23 26 28 2 pfet_01v8 L=1.5e-07 W=1.13e-06 $X=56890 $Y=397100 $dt=1
M52860 2 25 23 2 pfet_01v8 L=1.5e-07 W=1.13e-06 $X=57840 $Y=397100 $dt=1
M52861 23 25 2 2 pfet_01v8 L=1.5e-07 W=1.13e-06 $X=58270 $Y=397100 $dt=1
M52862 2 27 23 2 pfet_01v8 L=1.5e-07 W=1.13e-06 $X=58700 $Y=397100 $dt=1
M52863 23 27 2 2 pfet_01v8 L=1.5e-07 W=1.13e-06 $X=59130 $Y=397100 $dt=1
M52864 29 31 2 2 pfet_01v8 L=1.5e-07 W=6.25e-07 $X=76760 $Y=356205 $dt=1
M52865 2 33 29 2 pfet_01v8 L=1.5e-07 W=6.25e-07 $X=77190 $Y=356205 $dt=1
M52866 29 32 2 2 pfet_01v8 L=1.5e-07 W=6.25e-07 $X=77620 $Y=356205 $dt=1
M52867 2 29 30 2 pfet_01v8 L=1.5e-07 W=1.13e-06 $X=78570 $Y=355700 $dt=1
M52868 34 36 2 2 pfet_01v8 L=1.5e-07 W=7.8e-07 $X=88720 $Y=142535 $dt=1
M52869 2 38 34 2 pfet_01v8 L=1.5e-07 W=7.8e-07 $X=89150 $Y=142535 $dt=1
M52870 34 37 2 2 pfet_01v8 L=1.5e-07 W=7.8e-07 $X=89580 $Y=142535 $dt=1
M52871 2 34 35 2 pfet_01v8 L=1.5e-07 W=1.46e-06 $X=90070 $Y=142535 $dt=1
M52872 35 34 2 2 pfet_01v8 L=1.5e-07 W=1.46e-06 $X=90500 $Y=142535 $dt=1
M52873 47 52 2 2 pfet_01v8 L=1.5e-07 W=7.8e-07 $X=101600 $Y=306565 $dt=1
M52874 2 51 48 2 pfet_01v8 L=1.5e-07 W=7.8e-07 $X=102030 $Y=306565 $dt=1
M52875 48 47 49 2 pfet_01v8 L=1.5e-07 W=7.8e-07 $X=102460 $Y=306565 $dt=1
M52876 49 52 8174 2 pfet_01v8 L=1.5e-07 W=7.8e-07 $X=102890 $Y=306565 $dt=1
M52877 2 48 8174 2 pfet_01v8 L=1.5e-07 W=7.8e-07 $X=103320 $Y=306565 $dt=1
M52878 2 49 50 2 pfet_01v8 L=1.5e-07 W=1.46e-06 $X=103810 $Y=305885 $dt=1
M52879 50 49 2 2 pfet_01v8 L=1.5e-07 W=1.46e-06 $X=104240 $Y=305885 $dt=1
M52880 56 57 2 2 pfet_01v8 L=1.5e-07 W=6.25e-07 $X=104360 $Y=324890 $dt=1
M52881 2 58 53 2 pfet_01v8 L=1.5e-07 W=6.25e-07 $X=104790 $Y=324890 $dt=1
M52882 53 56 54 2 pfet_01v8 L=1.5e-07 W=6.25e-07 $X=105220 $Y=324890 $dt=1
M52883 54 57 8175 2 pfet_01v8 L=1.5e-07 W=6.25e-07 $X=105650 $Y=324890 $dt=1
M52884 8175 53 2 2 pfet_01v8 L=1.5e-07 W=6.25e-07 $X=106080 $Y=324890 $dt=1
M52885 2 54 55 2 pfet_01v8 L=1.5e-07 W=1.13e-06 $X=106570 $Y=324890 $dt=1
M52886 55 54 2 2 pfet_01v8 L=1.5e-07 W=1.13e-06 $X=107000 $Y=324890 $dt=1
M52887 45 40 2 2 pfet_01v8 L=1.5e-07 W=1.46e-06 $X=110340 $Y=231365 $dt=1
M52888 2 40 45 2 pfet_01v8 L=1.5e-07 W=1.46e-06 $X=110770 $Y=231365 $dt=1
M52889 45 42 44 2 pfet_01v8 L=1.5e-07 W=1.46e-06 $X=111200 $Y=231365 $dt=1
M52890 44 42 45 2 pfet_01v8 L=1.5e-07 W=1.46e-06 $X=111630 $Y=231365 $dt=1
M52891 46 41 44 2 pfet_01v8 L=1.5e-07 W=1.46e-06 $X=112580 $Y=231365 $dt=1
M52892 44 41 46 2 pfet_01v8 L=1.5e-07 W=1.46e-06 $X=113010 $Y=231365 $dt=1
M52893 46 43 39 2 pfet_01v8 L=1.5e-07 W=1.46e-06 $X=113440 $Y=231365 $dt=1
M52894 39 43 46 2 pfet_01v8 L=1.5e-07 W=1.46e-06 $X=113870 $Y=231365 $dt=1
M52895 2 71 67 2 pfet_01v8 L=1.5e-07 W=1.13e-06 $X=117240 $Y=167570 $dt=1
M52896 67 71 2 2 pfet_01v8 L=1.5e-07 W=1.13e-06 $X=117670 $Y=167570 $dt=1
M52897 2 70 69 2 pfet_01v8 L=1.5e-07 W=1.13e-06 $X=118100 $Y=167570 $dt=1
M52898 69 70 2 2 pfet_01v8 L=1.5e-07 W=1.13e-06 $X=118530 $Y=167570 $dt=1
M52899 68 72 67 2 pfet_01v8 L=1.5e-07 W=1.13e-06 $X=119480 $Y=167570 $dt=1
M52900 67 72 68 2 pfet_01v8 L=1.5e-07 W=1.13e-06 $X=119910 $Y=167570 $dt=1
M52901 68 73 69 2 pfet_01v8 L=1.5e-07 W=1.13e-06 $X=120340 $Y=167570 $dt=1
M52902 69 73 68 2 pfet_01v8 L=1.5e-07 W=1.13e-06 $X=120770 $Y=167570 $dt=1
M52903 75 78 2 2 pfet_01v8 L=1.5e-07 W=1.46e-06 $X=121380 $Y=266735 $dt=1
M52904 2 78 75 2 pfet_01v8 L=1.5e-07 W=1.46e-06 $X=121810 $Y=266735 $dt=1
M52905 75 79 77 2 pfet_01v8 L=1.5e-07 W=1.46e-06 $X=122240 $Y=266735 $dt=1
M52906 77 79 75 2 pfet_01v8 L=1.5e-07 W=1.46e-06 $X=122670 $Y=266735 $dt=1
M52907 76 80 2 2 pfet_01v8 L=1.5e-07 W=1.46e-06 $X=123620 $Y=266735 $dt=1
M52908 2 80 76 2 pfet_01v8 L=1.5e-07 W=1.46e-06 $X=124050 $Y=266735 $dt=1
M52909 76 81 77 2 pfet_01v8 L=1.5e-07 W=1.46e-06 $X=124480 $Y=266735 $dt=1
M52910 77 81 76 2 pfet_01v8 L=1.5e-07 W=1.46e-06 $X=124910 $Y=266735 $dt=1
M52911 2 82 77 2 pfet_01v8 L=1.5e-07 W=1.46e-06 $X=125860 $Y=266735 $dt=1
M52912 77 82 2 2 pfet_01v8 L=1.5e-07 W=1.46e-06 $X=126290 $Y=266735 $dt=1
M52913 60 63 2 2 pfet_01v8 L=1.5e-07 W=1.13e-06 $X=128280 $Y=142730 $dt=1
M52914 2 63 60 2 pfet_01v8 L=1.5e-07 W=1.13e-06 $X=128710 $Y=142730 $dt=1
M52915 60 61 2 2 pfet_01v8 L=1.5e-07 W=1.13e-06 $X=129140 $Y=142730 $dt=1
M52916 2 61 60 2 pfet_01v8 L=1.5e-07 W=1.13e-06 $X=129570 $Y=142730 $dt=1
M52917 59 64 60 2 pfet_01v8 L=1.5e-07 W=1.13e-06 $X=130520 $Y=142730 $dt=1
M52918 60 64 59 2 pfet_01v8 L=1.5e-07 W=1.13e-06 $X=130950 $Y=142730 $dt=1
M52919 59 62 65 2 pfet_01v8 L=1.5e-07 W=1.13e-06 $X=131380 $Y=142730 $dt=1
M52920 65 62 59 2 pfet_01v8 L=1.5e-07 W=1.13e-06 $X=131810 $Y=142730 $dt=1
M52921 85 90 2 2 pfet_01v8 L=1.5e-07 W=6.25e-07 $X=143920 $Y=397605 $dt=1
M52922 2 89 8176 2 pfet_01v8 L=1.5e-07 W=6.25e-07 $X=144350 $Y=397605 $dt=1
M52923 8176 88 86 2 pfet_01v8 L=1.5e-07 W=6.25e-07 $X=144780 $Y=397605 $dt=1
M52924 86 85 8177 2 pfet_01v8 L=1.5e-07 W=6.25e-07 $X=145210 $Y=397605 $dt=1
M52925 8177 87 2 2 pfet_01v8 L=1.5e-07 W=6.25e-07 $X=145640 $Y=397605 $dt=1
M52926 2 85 88 2 pfet_01v8 L=1.5e-07 W=6.25e-07 $X=146070 $Y=397605 $dt=1
M52927 2 86 87 2 pfet_01v8 L=1.5e-07 W=6.25e-07 $X=147020 $Y=397605 $dt=1
M52928 87 85 99 2 pfet_01v8 L=1.5e-07 W=6.25e-07 $X=147450 $Y=397605 $dt=1
M52929 99 88 8178 2 pfet_01v8 L=1.5e-07 W=6.25e-07 $X=147880 $Y=397605 $dt=1
M52930 2 100 8178 2 pfet_01v8 L=1.5e-07 W=6.25e-07 $X=148310 $Y=397605 $dt=1
M52931 2 99 100 2 pfet_01v8 L=1.5e-07 W=9.05e-07 $X=148800 $Y=397325 $dt=1
M52932 100 99 2 2 pfet_01v8 L=1.5e-07 W=9.05e-07 $X=149230 $Y=397325 $dt=1
M52933 96 100 2 2 pfet_01v8 L=1.5e-07 W=1.13e-06 $X=150180 $Y=397100 $dt=1
M52934 2 100 97 2 pfet_01v8 L=1.5e-07 W=1.13e-06 $X=150610 $Y=397100 $dt=1
M52935 97 100 2 2 pfet_01v8 L=1.5e-07 W=1.13e-06 $X=151040 $Y=397100 $dt=1
M52936 2 100 97 2 pfet_01v8 L=1.5e-07 W=1.13e-06 $X=151470 $Y=397100 $dt=1
M52937 97 100 2 2 pfet_01v8 L=1.5e-07 W=1.13e-06 $X=151900 $Y=397100 $dt=1
M52938 2 96 98 2 pfet_01v8 L=1.5e-07 W=1.13e-06 $X=152330 $Y=397100 $dt=1
M52939 98 96 2 2 pfet_01v8 L=1.5e-07 W=1.13e-06 $X=152760 $Y=397100 $dt=1
M52940 2 96 98 2 pfet_01v8 L=1.5e-07 W=1.13e-06 $X=153190 $Y=397100 $dt=1
M52941 98 96 2 2 pfet_01v8 L=1.5e-07 W=1.13e-06 $X=153620 $Y=397100 $dt=1
M52942 92 95 2 2 pfet_01v8 L=1.5e-07 W=6.25e-07 $X=160480 $Y=273405 $dt=1
M52943 2 93 92 2 pfet_01v8 L=1.5e-07 W=6.25e-07 $X=160910 $Y=273405 $dt=1
M52944 2 94 92 2 pfet_01v8 L=1.5e-07 W=6.25e-07 $X=161340 $Y=273405 $dt=1
M52945 2 92 91 2 pfet_01v8 L=1.5e-07 W=1.13e-06 $X=161830 $Y=272900 $dt=1
M52946 91 92 2 2 pfet_01v8 L=1.5e-07 W=1.13e-06 $X=162260 $Y=272900 $dt=1
M52947 2 102 101 2 pfet_01v8 L=1.5e-07 W=1.46e-06 $X=162440 $Y=399215 $dt=1
M52948 101 102 2 2 pfet_01v8 L=1.5e-07 W=1.46e-06 $X=162870 $Y=399215 $dt=1
M52949 2 102 101 2 pfet_01v8 L=1.5e-07 W=1.46e-06 $X=163300 $Y=399215 $dt=1
M52950 101 102 2 2 pfet_01v8 L=1.5e-07 W=1.46e-06 $X=163730 $Y=399215 $dt=1
M52951 2 102 101 2 pfet_01v8 L=1.5e-07 W=1.46e-06 $X=164160 $Y=399215 $dt=1
M52952 101 102 2 2 pfet_01v8 L=1.5e-07 W=1.46e-06 $X=164590 $Y=399215 $dt=1
M52953 2 108 102 2 pfet_01v8 L=1.5e-07 W=7.8e-07 $X=165080 $Y=399215 $dt=1
M52954 102 107 2 2 pfet_01v8 L=1.5e-07 W=7.8e-07 $X=165510 $Y=399215 $dt=1
M52955 104 109 2 2 pfet_01v8 L=1.5e-07 W=1.46e-06 $X=168760 $Y=399215 $dt=1
M52956 2 109 104 2 pfet_01v8 L=1.5e-07 W=1.46e-06 $X=169190 $Y=399215 $dt=1
M52957 104 109 2 2 pfet_01v8 L=1.5e-07 W=1.46e-06 $X=169620 $Y=399215 $dt=1
M52958 2 109 104 2 pfet_01v8 L=1.5e-07 W=1.46e-06 $X=170050 $Y=399215 $dt=1
M52959 104 110 106 2 pfet_01v8 L=1.5e-07 W=1.46e-06 $X=170480 $Y=399215 $dt=1
M52960 106 110 104 2 pfet_01v8 L=1.5e-07 W=1.46e-06 $X=170910 $Y=399215 $dt=1
M52961 104 110 106 2 pfet_01v8 L=1.5e-07 W=1.46e-06 $X=171340 $Y=399215 $dt=1
M52962 106 110 104 2 pfet_01v8 L=1.5e-07 W=1.46e-06 $X=171770 $Y=399215 $dt=1
M52963 103 111 106 2 pfet_01v8 L=1.5e-07 W=1.46e-06 $X=172720 $Y=399215 $dt=1
M52964 106 111 103 2 pfet_01v8 L=1.5e-07 W=1.46e-06 $X=173150 $Y=399215 $dt=1
M52965 103 111 106 2 pfet_01v8 L=1.5e-07 W=1.46e-06 $X=173580 $Y=399215 $dt=1
M52966 106 111 103 2 pfet_01v8 L=1.5e-07 W=1.46e-06 $X=174010 $Y=399215 $dt=1
M52967 103 112 105 2 pfet_01v8 L=1.5e-07 W=1.46e-06 $X=174440 $Y=399215 $dt=1
M52968 105 112 103 2 pfet_01v8 L=1.5e-07 W=1.46e-06 $X=174870 $Y=399215 $dt=1
M52969 103 112 105 2 pfet_01v8 L=1.5e-07 W=1.46e-06 $X=175300 $Y=399215 $dt=1
M52970 105 112 103 2 pfet_01v8 L=1.5e-07 W=1.46e-06 $X=175730 $Y=399215 $dt=1
M52971 124 120 2 2 pfet_01v8 L=1.5e-07 W=1.46e-06 $X=183940 $Y=322445 $dt=1
M52972 2 120 124 2 pfet_01v8 L=1.5e-07 W=1.46e-06 $X=184370 $Y=322445 $dt=1
M52973 124 120 2 2 pfet_01v8 L=1.5e-07 W=1.46e-06 $X=184800 $Y=322445 $dt=1
M52974 2 120 124 2 pfet_01v8 L=1.5e-07 W=1.46e-06 $X=185230 $Y=322445 $dt=1
M52975 124 121 123 2 pfet_01v8 L=1.5e-07 W=1.46e-06 $X=185660 $Y=322445 $dt=1
M52976 2 114 113 2 pfet_01v8 L=1.5e-07 W=1.46e-06 $X=185870 $Y=272765 $dt=1
M52977 123 121 124 2 pfet_01v8 L=1.5e-07 W=1.46e-06 $X=186090 $Y=322445 $dt=1
M52978 113 114 2 2 pfet_01v8 L=1.5e-07 W=1.46e-06 $X=186300 $Y=272765 $dt=1
M52979 124 121 123 2 pfet_01v8 L=1.5e-07 W=1.46e-06 $X=186520 $Y=322445 $dt=1
M52980 2 114 113 2 pfet_01v8 L=1.5e-07 W=1.46e-06 $X=186730 $Y=272765 $dt=1
M52981 123 121 124 2 pfet_01v8 L=1.5e-07 W=1.46e-06 $X=186950 $Y=322445 $dt=1
M52982 113 114 2 2 pfet_01v8 L=1.5e-07 W=1.46e-06 $X=187160 $Y=272765 $dt=1
M52983 2 116 8179 2 pfet_01v8 L=1.5e-07 W=1.25e-06 $X=187650 $Y=272975 $dt=1
M52984 119 122 123 2 pfet_01v8 L=1.5e-07 W=1.46e-06 $X=187900 $Y=322445 $dt=1
M52985 8179 115 114 2 pfet_01v8 L=1.5e-07 W=1.25e-06 $X=188080 $Y=272975 $dt=1
M52986 123 122 119 2 pfet_01v8 L=1.5e-07 W=1.46e-06 $X=188330 $Y=322445 $dt=1
M52987 114 118 8180 2 pfet_01v8 L=1.5e-07 W=1.25e-06 $X=188510 $Y=272975 $dt=1
M52988 119 122 123 2 pfet_01v8 L=1.5e-07 W=1.46e-06 $X=188760 $Y=322445 $dt=1
M52989 8180 117 2 2 pfet_01v8 L=1.5e-07 W=1.25e-06 $X=188940 $Y=272975 $dt=1
M52990 123 122 119 2 pfet_01v8 L=1.5e-07 W=1.46e-06 $X=189190 $Y=322445 $dt=1
M52991 2 118 115 2 pfet_01v8 L=1.5e-07 W=7.8e-07 $X=189430 $Y=273445 $dt=1
M52992 128 136 2 2 pfet_01v8 L=1.5e-07 W=6.25e-07 $X=348160 $Y=107805 $dt=1
M52993 2 134 8181 2 pfet_01v8 L=1.5e-07 W=6.25e-07 $X=348590 $Y=107805 $dt=1
M52994 8181 130 129 2 pfet_01v8 L=1.5e-07 W=6.25e-07 $X=349020 $Y=107805 $dt=1
M52995 129 128 137 2 pfet_01v8 L=1.5e-07 W=6.25e-07 $X=349450 $Y=107805 $dt=1
M52996 137 131 2 2 pfet_01v8 L=1.5e-07 W=6.25e-07 $X=349880 $Y=107805 $dt=1
M52997 2 135 137 2 pfet_01v8 L=1.5e-07 W=6.25e-07 $X=350310 $Y=107805 $dt=1
M52998 130 128 2 2 pfet_01v8 L=1.5e-07 W=6.25e-07 $X=351260 $Y=107805 $dt=1
M52999 2 129 131 2 pfet_01v8 L=1.5e-07 W=6.25e-07 $X=351690 $Y=107805 $dt=1
M53000 131 128 132 2 pfet_01v8 L=1.5e-07 W=6.25e-07 $X=352120 $Y=107805 $dt=1
M53001 132 130 8182 2 pfet_01v8 L=1.5e-07 W=6.25e-07 $X=352550 $Y=107805 $dt=1
M53002 8182 133 2 2 pfet_01v8 L=1.5e-07 W=6.25e-07 $X=352980 $Y=107805 $dt=1
M53003 2 132 133 2 pfet_01v8 L=1.5e-07 W=6.25e-07 $X=353930 $Y=107805 $dt=1
M53004 133 135 2 2 pfet_01v8 L=1.5e-07 W=6.25e-07 $X=354360 $Y=107805 $dt=1
M53005 2 133 125 2 pfet_01v8 L=1.5e-07 W=6.25e-07 $X=354790 $Y=107805 $dt=1
M53006 126 133 2 2 pfet_01v8 L=1.5e-07 W=1.13e-06 $X=355740 $Y=107300 $dt=1
M53007 2 125 127 2 pfet_01v8 L=1.5e-07 W=1.13e-06 $X=356170 $Y=107300 $dt=1
M53008 20 16 12 VSS: nfet_01v8_lvt L=1.5e-07 W=7.6e-07 $X=35540 $Y=401805 $dt=3
M53009 12 16 20 VSS: nfet_01v8_lvt L=1.5e-07 W=7.6e-07 $X=35970 $Y=401805 $dt=3
M53010 20 13 12 VSS: nfet_01v8_lvt L=1.5e-07 W=7.6e-07 $X=36400 $Y=401805 $dt=3
M53011 12 13 20 VSS: nfet_01v8_lvt L=1.5e-07 W=7.6e-07 $X=36830 $Y=401805 $dt=3
M53012 19 17 20 VSS: nfet_01v8_lvt L=1.5e-07 W=7.6e-07 $X=37780 $Y=401805 $dt=3
M53013 20 17 19 VSS: nfet_01v8_lvt L=1.5e-07 W=7.6e-07 $X=38210 $Y=401805 $dt=3
M53014 19 14 20 VSS: nfet_01v8_lvt L=1.5e-07 W=7.6e-07 $X=38640 $Y=401805 $dt=3
M53015 20 14 19 VSS: nfet_01v8_lvt L=1.5e-07 W=7.6e-07 $X=39070 $Y=401805 $dt=3
M53016 19 18 VSS: VSS: nfet_01v8_lvt L=1.5e-07 W=7.6e-07 $X=40020 $Y=401805 $dt=3
M53017 VSS: 18 19 VSS: nfet_01v8_lvt L=1.5e-07 W=7.6e-07 $X=40450 $Y=401805 $dt=3
M53018 19 15 VSS: VSS: nfet_01v8_lvt L=1.5e-07 W=7.6e-07 $X=40880 $Y=401805 $dt=3
M53019 VSS: 15 19 VSS: nfet_01v8_lvt L=1.5e-07 W=7.6e-07 $X=41310 $Y=401805 $dt=3
M53020 3 7 8183 VSS: nfet_01v8_lvt L=1.5e-07 W=4.25e-07 $X=46860 $Y=244625 $dt=3
M53021 8183 5 8184 VSS: nfet_01v8_lvt L=1.5e-07 W=4.25e-07 $X=47290 $Y=244625 $dt=3
M53022 8184 8 8185 VSS: nfet_01v8_lvt L=1.5e-07 W=4.25e-07 $X=47720 $Y=244625 $dt=3
M53023 8185 6 VSS: VSS: nfet_01v8_lvt L=1.5e-07 W=4.25e-07 $X=48150 $Y=244625 $dt=3
M53024 VSS: 3 4 VSS: nfet_01v8_lvt L=1.5e-07 W=7.6e-07 $X=48640 $Y=244290 $dt=3
M53025 34 36 8188 VSS: nfet_01v8_lvt L=1.5e-07 W=4.25e-07 $X=88720 $Y=145460 $dt=3
M53026 8188 38 8189 VSS: nfet_01v8_lvt L=1.5e-07 W=4.25e-07 $X=89150 $Y=145460 $dt=3
M53027 8189 37 VSS: VSS: nfet_01v8_lvt L=1.5e-07 W=4.25e-07 $X=89580 $Y=145460 $dt=3
M53028 VSS: 34 35 VSS: nfet_01v8_lvt L=1.5e-07 W=7.6e-07 $X=90070 $Y=145125 $dt=3
M53029 35 34 VSS: VSS: nfet_01v8_lvt L=1.5e-07 W=7.6e-07 $X=90500 $Y=145125 $dt=3
M53030 47 52 VSS: VSS: nfet_01v8_lvt L=1.5e-07 W=4.25e-07 $X=101600 $Y=304070 $dt=3
M53031 VSS: 51 48 VSS: nfet_01v8_lvt L=1.5e-07 W=4.25e-07 $X=102030 $Y=304070 $dt=3
M53032 48 52 49 VSS: nfet_01v8_lvt L=1.5e-07 W=4.25e-07 $X=102460 $Y=304070 $dt=3
M53033 49 47 8190 VSS: nfet_01v8_lvt L=1.5e-07 W=4.25e-07 $X=102890 $Y=304070 $dt=3
M53034 8190 48 VSS: VSS: nfet_01v8_lvt L=1.5e-07 W=4.25e-07 $X=103320 $Y=304070 $dt=3
M53035 VSS: 49 50 VSS: nfet_01v8_lvt L=1.5e-07 W=7.6e-07 $X=103810 $Y=304070 $dt=3
M53036 50 49 VSS: VSS: nfet_01v8_lvt L=1.5e-07 W=7.6e-07 $X=104240 $Y=304070 $dt=3
M53037 VSS: 40 39 VSS: nfet_01v8_lvt L=1.5e-07 W=7.6e-07 $X=110340 $Y=229475 $dt=3
M53038 39 40 VSS: VSS: nfet_01v8_lvt L=1.5e-07 W=7.6e-07 $X=110770 $Y=229475 $dt=3
M53039 VSS: 42 39 VSS: nfet_01v8_lvt L=1.5e-07 W=7.6e-07 $X=111200 $Y=229475 $dt=3
M53040 39 42 VSS: VSS: nfet_01v8_lvt L=1.5e-07 W=7.6e-07 $X=111630 $Y=229475 $dt=3
M53041 VSS: 41 39 VSS: nfet_01v8_lvt L=1.5e-07 W=7.6e-07 $X=112580 $Y=229475 $dt=3
M53042 39 41 VSS: VSS: nfet_01v8_lvt L=1.5e-07 W=7.6e-07 $X=113010 $Y=229475 $dt=3
M53043 VSS: 43 39 VSS: nfet_01v8_lvt L=1.5e-07 W=7.6e-07 $X=113440 $Y=229475 $dt=3
M53044 39 43 VSS: VSS: nfet_01v8_lvt L=1.5e-07 W=7.6e-07 $X=113870 $Y=229475 $dt=3
M53045 VSS: 78 83 VSS: nfet_01v8_lvt L=1.5e-07 W=7.6e-07 $X=121380 $Y=269325 $dt=3
M53046 83 78 VSS: VSS: nfet_01v8_lvt L=1.5e-07 W=7.6e-07 $X=121810 $Y=269325 $dt=3
M53047 VSS: 79 83 VSS: nfet_01v8_lvt L=1.5e-07 W=7.6e-07 $X=122240 $Y=269325 $dt=3
M53048 83 79 VSS: VSS: nfet_01v8_lvt L=1.5e-07 W=7.6e-07 $X=122670 $Y=269325 $dt=3
M53049 83 80 84 VSS: nfet_01v8_lvt L=1.5e-07 W=7.6e-07 $X=123620 $Y=269325 $dt=3
M53050 84 80 83 VSS: nfet_01v8_lvt L=1.5e-07 W=7.6e-07 $X=124050 $Y=269325 $dt=3
M53051 83 81 84 VSS: nfet_01v8_lvt L=1.5e-07 W=7.6e-07 $X=124480 $Y=269325 $dt=3
M53052 84 81 83 VSS: nfet_01v8_lvt L=1.5e-07 W=7.6e-07 $X=124910 $Y=269325 $dt=3
M53053 84 82 77 VSS: nfet_01v8_lvt L=1.5e-07 W=7.6e-07 $X=125860 $Y=269325 $dt=3
M53054 77 82 84 VSS: nfet_01v8_lvt L=1.5e-07 W=7.6e-07 $X=126290 $Y=269325 $dt=3
M53055 VSS: 102 101 VSS: nfet_01v8_lvt L=1.5e-07 W=7.6e-07 $X=164160 $Y=401805 $dt=3
M53056 101 102 VSS: VSS: nfet_01v8_lvt L=1.5e-07 W=7.6e-07 $X=164590 $Y=401805 $dt=3
M53057 VSS: 108 8197 VSS: nfet_01v8_lvt L=1.5e-07 W=4.25e-07 $X=165080 $Y=402140 $dt=3
M53058 8197 107 102 VSS: nfet_01v8_lvt L=1.5e-07 W=4.25e-07 $X=165510 $Y=402140 $dt=3
M53059 VSS: 109 105 VSS: nfet_01v8_lvt L=1.5e-07 W=7.6e-07 $X=168760 $Y=401805 $dt=3
M53060 105 109 VSS: VSS: nfet_01v8_lvt L=1.5e-07 W=7.6e-07 $X=169190 $Y=401805 $dt=3
M53061 VSS: 109 105 VSS: nfet_01v8_lvt L=1.5e-07 W=7.6e-07 $X=169620 $Y=401805 $dt=3
M53062 105 109 VSS: VSS: nfet_01v8_lvt L=1.5e-07 W=7.6e-07 $X=170050 $Y=401805 $dt=3
M53063 VSS: 110 105 VSS: nfet_01v8_lvt L=1.5e-07 W=7.6e-07 $X=170480 $Y=401805 $dt=3
M53064 105 110 VSS: VSS: nfet_01v8_lvt L=1.5e-07 W=7.6e-07 $X=170910 $Y=401805 $dt=3
M53065 VSS: 110 105 VSS: nfet_01v8_lvt L=1.5e-07 W=7.6e-07 $X=171340 $Y=401805 $dt=3
M53066 105 110 VSS: VSS: nfet_01v8_lvt L=1.5e-07 W=7.6e-07 $X=171770 $Y=401805 $dt=3
M53067 VSS: 111 105 VSS: nfet_01v8_lvt L=1.5e-07 W=7.6e-07 $X=172720 $Y=401805 $dt=3
M53068 105 111 VSS: VSS: nfet_01v8_lvt L=1.5e-07 W=7.6e-07 $X=173150 $Y=401805 $dt=3
M53069 VSS: 111 105 VSS: nfet_01v8_lvt L=1.5e-07 W=7.6e-07 $X=173580 $Y=401805 $dt=3
M53070 105 111 VSS: VSS: nfet_01v8_lvt L=1.5e-07 W=7.6e-07 $X=174010 $Y=401805 $dt=3
M53071 VSS: 112 105 VSS: nfet_01v8_lvt L=1.5e-07 W=7.6e-07 $X=174440 $Y=401805 $dt=3
M53072 105 112 VSS: VSS: nfet_01v8_lvt L=1.5e-07 W=7.6e-07 $X=174870 $Y=401805 $dt=3
M53073 VSS: 112 105 VSS: nfet_01v8_lvt L=1.5e-07 W=7.6e-07 $X=175300 $Y=401805 $dt=3
M53074 105 112 VSS: VSS: nfet_01v8_lvt L=1.5e-07 W=7.6e-07 $X=175730 $Y=401805 $dt=3
M53075 VSS: 120 119 VSS: nfet_01v8_lvt L=1.5e-07 W=7.6e-07 $X=183940 $Y=320555 $dt=3
M53076 119 120 VSS: VSS: nfet_01v8_lvt L=1.5e-07 W=7.6e-07 $X=184370 $Y=320555 $dt=3
M53077 VSS: 120 119 VSS: nfet_01v8_lvt L=1.5e-07 W=7.6e-07 $X=184800 $Y=320555 $dt=3
M53078 119 120 VSS: VSS: nfet_01v8_lvt L=1.5e-07 W=7.6e-07 $X=185230 $Y=320555 $dt=3
M53079 VSS: 121 119 VSS: nfet_01v8_lvt L=1.5e-07 W=7.6e-07 $X=185660 $Y=320555 $dt=3
M53080 VSS: 114 113 VSS: nfet_01v8_lvt L=1.5e-07 W=7.6e-07 $X=185870 $Y=270875 $dt=3
M53081 119 121 VSS: VSS: nfet_01v8_lvt L=1.5e-07 W=7.6e-07 $X=186090 $Y=320555 $dt=3
M53082 113 114 VSS: VSS: nfet_01v8_lvt L=1.5e-07 W=7.6e-07 $X=186300 $Y=270875 $dt=3
M53083 VSS: 121 119 VSS: nfet_01v8_lvt L=1.5e-07 W=7.6e-07 $X=186520 $Y=320555 $dt=3
M53084 VSS: 114 113 VSS: nfet_01v8_lvt L=1.5e-07 W=7.6e-07 $X=186730 $Y=270875 $dt=3
M53085 119 121 VSS: VSS: nfet_01v8_lvt L=1.5e-07 W=7.6e-07 $X=186950 $Y=320555 $dt=3
M53086 113 114 VSS: VSS: nfet_01v8_lvt L=1.5e-07 W=7.6e-07 $X=187160 $Y=270875 $dt=3
M53087 VSS: 116 8198 VSS: nfet_01v8_lvt L=1.5e-07 W=6e-07 $X=187650 $Y=270875 $dt=3
M53088 VSS: 122 119 VSS: nfet_01v8_lvt L=1.5e-07 W=7.6e-07 $X=187900 $Y=320555 $dt=3
M53089 8198 118 114 VSS: nfet_01v8_lvt L=1.5e-07 W=6e-07 $X=188080 $Y=270875 $dt=3
M53090 119 122 VSS: VSS: nfet_01v8_lvt L=1.5e-07 W=7.6e-07 $X=188330 $Y=320555 $dt=3
M53091 114 115 8199 VSS: nfet_01v8_lvt L=1.5e-07 W=6e-07 $X=188510 $Y=270875 $dt=3
M53092 VSS: 122 119 VSS: nfet_01v8_lvt L=1.5e-07 W=7.6e-07 $X=188760 $Y=320555 $dt=3
M53093 8199 117 VSS: VSS: nfet_01v8_lvt L=1.5e-07 W=6e-07 $X=188940 $Y=270875 $dt=3
M53094 119 122 VSS: VSS: nfet_01v8_lvt L=1.5e-07 W=7.6e-07 $X=189190 $Y=320555 $dt=3
M53095 VSS: 118 115 VSS: nfet_01v8_lvt L=1.5e-07 W=4.25e-07 $X=189430 $Y=270875 $dt=3
** N=276680 EP=87 NDC=334 FDC=103890 HDC=1552
.ends chip_top
